* NGSPICE file created from Control_unit.ext - technology: sky130A

* Black-box entry subcircuit for sky130_fd_sc_hd__fill_1 abstract view
.subckt sky130_fd_sc_hd__fill_1 VGND VNB VPB VPWR
.ends

* Black-box entry subcircuit for sky130_fd_sc_hd__fill_2 abstract view
.subckt sky130_fd_sc_hd__fill_2 VGND VNB VPB VPWR
.ends

* Black-box entry subcircuit for sky130_fd_sc_hd__decap_3 abstract view
.subckt sky130_fd_sc_hd__decap_3 VGND VNB VPB VPWR
.ends

* Black-box entry subcircuit for sky130_fd_sc_hd__buf_2 abstract view
.subckt sky130_fd_sc_hd__buf_2 A VGND VNB VPB VPWR X
.ends

* Black-box entry subcircuit for sky130_fd_sc_hd__decap_4 abstract view
.subckt sky130_fd_sc_hd__decap_4 VGND VNB VPB VPWR
.ends

* Black-box entry subcircuit for sky130_fd_sc_hd__and4_1 abstract view
.subckt sky130_fd_sc_hd__and4_1 A B C D VGND VNB VPB VPWR X
.ends

* Black-box entry subcircuit for sky130_fd_sc_hd__and3b_1 abstract view
.subckt sky130_fd_sc_hd__and3b_1 A_N B C VGND VNB VPB VPWR X
.ends

* Black-box entry subcircuit for sky130_fd_sc_hd__tapvpwrvgnd_1 abstract view
.subckt sky130_fd_sc_hd__tapvpwrvgnd_1 VGND VPWR
.ends

* Black-box entry subcircuit for sky130_fd_sc_hd__and2_1 abstract view
.subckt sky130_fd_sc_hd__and2_1 A B VGND VNB VPB VPWR X
.ends

* Black-box entry subcircuit for sky130_fd_sc_hd__a32o_1 abstract view
.subckt sky130_fd_sc_hd__a32o_1 A1 A2 A3 B1 B2 VGND VNB VPB VPWR X
.ends

* Black-box entry subcircuit for sky130_fd_sc_hd__decap_8 abstract view
.subckt sky130_fd_sc_hd__decap_8 VGND VNB VPB VPWR
.ends

* Black-box entry subcircuit for sky130_fd_sc_hd__a22o_1 abstract view
.subckt sky130_fd_sc_hd__a22o_1 A1 A2 B1 B2 VGND VNB VPB VPWR X
.ends

* Black-box entry subcircuit for sky130_fd_sc_hd__or2_1 abstract view
.subckt sky130_fd_sc_hd__or2_1 A B VGND VNB VPB VPWR X
.ends

* Black-box entry subcircuit for sky130_fd_sc_hd__and2b_1 abstract view
.subckt sky130_fd_sc_hd__and2b_1 A_N B VGND VNB VPB VPWR X
.ends

* Black-box entry subcircuit for sky130_fd_sc_hd__a221o_1 abstract view
.subckt sky130_fd_sc_hd__a221o_1 A1 A2 B1 B2 C1 VGND VNB VPB VPWR X
.ends

* Black-box entry subcircuit for sky130_fd_sc_hd__nor3_1 abstract view
.subckt sky130_fd_sc_hd__nor3_1 A B C VGND VNB VPB VPWR Y
.ends

* Black-box entry subcircuit for sky130_fd_sc_hd__buf_1 abstract view
.subckt sky130_fd_sc_hd__buf_1 A VGND VNB VPB VPWR X
.ends

* Black-box entry subcircuit for sky130_fd_sc_hd__clkbuf_1 abstract view
.subckt sky130_fd_sc_hd__clkbuf_1 A VGND VNB VPB VPWR X
.ends

* Black-box entry subcircuit for sky130_fd_sc_hd__nor4_1 abstract view
.subckt sky130_fd_sc_hd__nor4_1 A B C D VGND VNB VPB VPWR Y
.ends

* Black-box entry subcircuit for sky130_fd_sc_hd__o21ai_1 abstract view
.subckt sky130_fd_sc_hd__o21ai_1 A1 A2 B1 VGND VNB VPB VPWR Y
.ends

* Black-box entry subcircuit for sky130_ef_sc_hd__decap_12 abstract view
.subckt sky130_ef_sc_hd__decap_12 VPWR VGND VPB VNB
.ends

* Black-box entry subcircuit for sky130_fd_sc_hd__nand2_1 abstract view
.subckt sky130_fd_sc_hd__nand2_1 A B VGND VNB VPB VPWR Y
.ends

* Black-box entry subcircuit for sky130_fd_sc_hd__a21o_1 abstract view
.subckt sky130_fd_sc_hd__a21o_1 A1 A2 B1 VGND VNB VPB VPWR X
.ends

* Black-box entry subcircuit for sky130_fd_sc_hd__nand2b_1 abstract view
.subckt sky130_fd_sc_hd__nand2b_1 A_N B VGND VNB VPB VPWR Y
.ends

* Black-box entry subcircuit for sky130_fd_sc_hd__a31o_1 abstract view
.subckt sky130_fd_sc_hd__a31o_1 A1 A2 A3 B1 VGND VNB VPB VPWR X
.ends

* Black-box entry subcircuit for sky130_fd_sc_hd__xor2_1 abstract view
.subckt sky130_fd_sc_hd__xor2_1 A B VGND VNB VPB VPWR X
.ends

* Black-box entry subcircuit for sky130_fd_sc_hd__nor2_1 abstract view
.subckt sky130_fd_sc_hd__nor2_1 A B VGND VNB VPB VPWR Y
.ends

* Black-box entry subcircuit for sky130_fd_sc_hd__inv_2 abstract view
.subckt sky130_fd_sc_hd__inv_2 A VGND VNB VPB VPWR Y
.ends

.subckt Control_unit ALUControl[0] ALUControl[1] ALUControl[2] ALUControl[3] ALUSrc
+ ImmSrc[0] ImmSrc[1] MemWrite PCSrc RegWrite ResultSrc VGND VPWR func[0] func[1]
+ func[2] func[3] opcode[0] opcode[1] opcode[2] zero
XFILLER_0_13 VGND VGND VPWR VPWR sky130_fd_sc_hd__fill_1
XFILLER_0_35 VGND VGND VPWR VPWR sky130_fd_sc_hd__fill_2
XPHY_EDGE_ROW_6_Right_6 VGND VGND VPWR VPWR sky130_fd_sc_hd__decap_3
Xoutput10 net10 VGND VGND VPWR VPWR ALUControl[1] sky130_fd_sc_hd__buf_2
XFILLER_3_3 VGND VGND VPWR VPWR sky130_fd_sc_hd__decap_4
Xoutput11 net11 VGND VGND VPWR VPWR ALUControl[2] sky130_fd_sc_hd__buf_2
Xoutput9 net9 VGND VGND VPWR VPWR ALUControl[0] sky130_fd_sc_hd__buf_2
XFILLER_5_7 VGND VGND VPWR VPWR sky130_fd_sc_hd__fill_1
XFILLER_0_27 VGND VGND VPWR VPWR sky130_fd_sc_hd__fill_1
X_29_ net23 _00_ net4 net3 VGND VGND VPWR VPWR _08_ sky130_fd_sc_hd__and4_1
Xoutput12 net12 VGND VGND VPWR VPWR ALUControl[3] sky130_fd_sc_hd__buf_2
XFILLER_6_26 VGND VGND VPWR VPWR sky130_fd_sc_hd__fill_2
X_28_ net6 net23 net22 VGND VGND VPWR VPWR net15 sky130_fd_sc_hd__and3b_1
Xoutput13 net13 VGND VGND VPWR VPWR ALUSrc sky130_fd_sc_hd__buf_2
XTAP_TAPCELL_ROW_2_17 VGND VPWR sky130_fd_sc_hd__tapvpwrvgnd_1
X_27_ net4 net21 VGND VGND VPWR VPWR net12 sky130_fd_sc_hd__and2_1
Xoutput14 net14 VGND VGND VPWR VPWR ImmSrc[0] sky130_fd_sc_hd__buf_2
XFILLER_3_7 VGND VGND VPWR VPWR sky130_fd_sc_hd__fill_1
X_26_ net2 net1 _03_ net21 net3 VGND VGND VPWR VPWR net11 sky130_fd_sc_hd__a32o_1
XPHY_EDGE_ROW_1_Right_1 VGND VGND VPWR VPWR sky130_fd_sc_hd__decap_3
Xoutput15 net15 VGND VGND VPWR VPWR ImmSrc[1] sky130_fd_sc_hd__buf_2
XFILLER_6_18 VGND VGND VPWR VPWR sky130_fd_sc_hd__decap_8
X_25_ net2 net21 _07_ net20 VGND VGND VPWR VPWR net10 sky130_fd_sc_hd__a22o_1
XPHY_EDGE_ROW_3_Left_11 VGND VGND VPWR VPWR sky130_fd_sc_hd__decap_3
Xoutput16 net16 VGND VGND VPWR VPWR MemWrite sky130_fd_sc_hd__buf_2
X_24_ _04_ _06_ VGND VGND VPWR VPWR _07_ sky130_fd_sc_hd__or2_1
Xoutput17 net17 VGND VGND VPWR VPWR PCSrc sky130_fd_sc_hd__buf_2
XFILLER_4_20 VGND VGND VPWR VPWR sky130_fd_sc_hd__fill_1
XFILLER_1_10 VGND VGND VPWR VPWR sky130_fd_sc_hd__decap_8
X_23_ net2 net1 VGND VGND VPWR VPWR _06_ sky130_fd_sc_hd__and2b_1
Xoutput18 net18 VGND VGND VPWR VPWR RegWrite sky130_fd_sc_hd__buf_2
XPHY_EDGE_ROW_5_Right_5 VGND VGND VPWR VPWR sky130_fd_sc_hd__decap_3
XPHY_EDGE_ROW_0_Left_8 VGND VGND VPWR VPWR sky130_fd_sc_hd__decap_3
X_22_ net20 _04_ net21 net1 net14 VGND VGND VPWR VPWR net9 sky130_fd_sc_hd__a221o_1
XFILLER_1_44 VGND VGND VPWR VPWR sky130_fd_sc_hd__fill_1
Xoutput19 net19 VGND VGND VPWR VPWR ResultSrc sky130_fd_sc_hd__buf_2
XPHY_EDGE_ROW_7_Left_15 VGND VGND VPWR VPWR sky130_fd_sc_hd__decap_3
XFILLER_7_21 VGND VGND VPWR VPWR sky130_fd_sc_hd__decap_3
X_21_ net7 net5 net6 VGND VGND VPWR VPWR _05_ sky130_fd_sc_hd__nor3_1
XFILLER_4_34 VGND VGND VPWR VPWR sky130_fd_sc_hd__decap_4
Xfanout22 net7 VGND VGND VPWR VPWR net22 sky130_fd_sc_hd__buf_1
Xinput1 func[0] VGND VGND VPWR VPWR net1 sky130_fd_sc_hd__buf_1
X_20_ net23 _00_ net22 VGND VGND VPWR VPWR net14 sky130_fd_sc_hd__and3b_1
XFILLER_7_12 VGND VGND VPWR VPWR sky130_fd_sc_hd__fill_1
Xfanout23 net5 VGND VGND VPWR VPWR net23 sky130_fd_sc_hd__buf_1
Xinput2 func[1] VGND VGND VPWR VPWR net2 sky130_fd_sc_hd__buf_1
Xmax_cap20 _03_ VGND VGND VPWR VPWR net20 sky130_fd_sc_hd__clkbuf_1
Xinput3 func[2] VGND VGND VPWR VPWR net3 sky130_fd_sc_hd__buf_1
XPHY_EDGE_ROW_0_Right_0 VGND VGND VPWR VPWR sky130_fd_sc_hd__decap_3
XTAP_TAPCELL_ROW_0_16 VGND VPWR sky130_fd_sc_hd__tapvpwrvgnd_1
Xinput4 func[3] VGND VGND VPWR VPWR net4 sky130_fd_sc_hd__clkbuf_1
XPHY_EDGE_ROW_2_Left_10 VGND VGND VPWR VPWR sky130_fd_sc_hd__decap_3
XFILLER_4_16 VGND VGND VPWR VPWR sky130_fd_sc_hd__decap_4
Xinput5 opcode[0] VGND VGND VPWR VPWR net5 sky130_fd_sc_hd__buf_1
XFILLER_7_16 VGND VGND VPWR VPWR sky130_fd_sc_hd__fill_1
XFILLER_7_27 VGND VGND VPWR VPWR sky130_fd_sc_hd__fill_1
XFILLER_1_18 VGND VGND VPWR VPWR sky130_fd_sc_hd__decap_3
XPHY_EDGE_ROW_1_Left_9 VGND VGND VPWR VPWR sky130_fd_sc_hd__decap_3
Xinput6 opcode[1] VGND VGND VPWR VPWR net6 sky130_fd_sc_hd__buf_1
XPHY_EDGE_ROW_4_Right_4 VGND VGND VPWR VPWR sky130_fd_sc_hd__decap_3
XFILLER_6_6 VGND VGND VPWR VPWR sky130_fd_sc_hd__fill_2
Xinput7 opcode[2] VGND VGND VPWR VPWR net7 sky130_fd_sc_hd__buf_1
XPHY_EDGE_ROW_6_Left_14 VGND VGND VPWR VPWR sky130_fd_sc_hd__decap_3
XFILLER_7_29 VGND VGND VPWR VPWR sky130_fd_sc_hd__decap_8
XFILLER_5_40 VGND VGND VPWR VPWR sky130_fd_sc_hd__fill_1
Xinput8 zero VGND VGND VPWR VPWR net8 sky130_fd_sc_hd__clkbuf_1
XTAP_TAPCELL_ROW_6_19 VGND VPWR sky130_fd_sc_hd__tapvpwrvgnd_1
XTAP_TAPCELL_ROW_7_20 VGND VPWR sky130_fd_sc_hd__tapvpwrvgnd_1
XFILLER_4_7 VGND VGND VPWR VPWR sky130_fd_sc_hd__fill_2
X_19_ net1 net2 VGND VGND VPWR VPWR _04_ sky130_fd_sc_hd__and2b_1
X_18_ net7 net4 net3 _02_ VGND VGND VPWR VPWR _03_ sky130_fd_sc_hd__nor4_1
XFILLER_5_23 VGND VGND VPWR VPWR sky130_fd_sc_hd__fill_1
X_17_ net22 net5 _02_ VGND VGND VPWR VPWR net18 sky130_fd_sc_hd__o21ai_1
XFILLER_2_7 VPWR VGND VPWR VGND sky130_ef_sc_hd__decap_12
X_16_ _01_ _02_ VGND VGND VPWR VPWR net13 sky130_fd_sc_hd__nand2_1
XPHY_EDGE_ROW_3_Right_3 VGND VGND VPWR VPWR sky130_fd_sc_hd__decap_3
X_32_ _06_ _08_ _10_ VGND VGND VPWR VPWR net17 sky130_fd_sc_hd__a21o_1
XPHY_EDGE_ROW_5_Left_13 VGND VGND VPWR VPWR sky130_fd_sc_hd__decap_3
X_15_ net6 net23 VGND VGND VPWR VPWR _02_ sky130_fd_sc_hd__nand2b_1
XFILLER_5_15 VGND VGND VPWR VPWR sky130_fd_sc_hd__decap_8
XFILLER_2_27 VGND VGND VPWR VPWR sky130_fd_sc_hd__fill_1
XFILLER_2_38 VGND VGND VPWR VPWR sky130_fd_sc_hd__decap_4
X_31_ net22 _00_ _09_ net15 VGND VGND VPWR VPWR _10_ sky130_fd_sc_hd__a31o_1
Xwire21 _05_ VGND VGND VPWR VPWR net21 sky130_fd_sc_hd__buf_1
X_14_ net22 net23 net6 VGND VGND VPWR VPWR net16 sky130_fd_sc_hd__and3b_1
X_30_ net1 net8 VGND VGND VPWR VPWR _09_ sky130_fd_sc_hd__xor2_1
X_13_ net23 _01_ VGND VGND VPWR VPWR net19 sky130_fd_sc_hd__nor2_1
XPHY_EDGE_ROW_7_Right_7 VGND VGND VPWR VPWR sky130_fd_sc_hd__decap_3
XFILLER_5_28 VGND VGND VPWR VPWR sky130_fd_sc_hd__decap_3
XFILLER_2_29 VGND VGND VPWR VPWR sky130_fd_sc_hd__fill_1
XTAP_TAPCELL_ROW_4_18 VGND VPWR sky130_fd_sc_hd__tapvpwrvgnd_1
X_12_ net22 _00_ VGND VGND VPWR VPWR _01_ sky130_fd_sc_hd__or2_1
XFILLER_2_19 VGND VGND VPWR VPWR sky130_fd_sc_hd__decap_8
XFILLER_0_9 VGND VGND VPWR VPWR sky130_fd_sc_hd__decap_4
X_11_ net6 VGND VGND VPWR VPWR _00_ sky130_fd_sc_hd__inv_2
XFILLER_3_42 VGND VGND VPWR VPWR sky130_fd_sc_hd__decap_3
XFILLER_3_21 VPWR VGND VPWR VGND sky130_ef_sc_hd__decap_12
XFILLER_6_43 VGND VGND VPWR VPWR sky130_fd_sc_hd__fill_2
XPHY_EDGE_ROW_2_Right_2 VGND VGND VPWR VPWR sky130_fd_sc_hd__decap_3
XFILLER_3_33 VGND VGND VPWR VPWR sky130_fd_sc_hd__decap_4
XFILLER_7_6 VGND VGND VPWR VPWR sky130_fd_sc_hd__decap_3
XPHY_EDGE_ROW_4_Left_12 VGND VGND VPWR VPWR sky130_fd_sc_hd__decap_3
.ends
