* NGSPICE file created from Register_file.ext - technology: sky130A

* Black-box entry subcircuit for sky130_fd_sc_hd__mux2_1 abstract view
.subckt sky130_fd_sc_hd__mux2_1 A0 A1 S VGND VNB VPB VPWR X
.ends

* Black-box entry subcircuit for sky130_fd_sc_hd__fill_2 abstract view
.subckt sky130_fd_sc_hd__fill_2 VGND VNB VPB VPWR
.ends

* Black-box entry subcircuit for sky130_fd_sc_hd__decap_3 abstract view
.subckt sky130_fd_sc_hd__decap_3 VGND VNB VPB VPWR
.ends

* Black-box entry subcircuit for sky130_fd_sc_hd__and2_1 abstract view
.subckt sky130_fd_sc_hd__and2_1 A B VGND VNB VPB VPWR X
.ends

* Black-box entry subcircuit for sky130_fd_sc_hd__decap_8 abstract view
.subckt sky130_fd_sc_hd__decap_8 VGND VNB VPB VPWR
.ends

* Black-box entry subcircuit for sky130_fd_sc_hd__tapvpwrvgnd_1 abstract view
.subckt sky130_fd_sc_hd__tapvpwrvgnd_1 VGND VPWR
.ends

* Black-box entry subcircuit for sky130_fd_sc_hd__decap_4 abstract view
.subckt sky130_fd_sc_hd__decap_4 VGND VNB VPB VPWR
.ends

* Black-box entry subcircuit for sky130_fd_sc_hd__mux4_1 abstract view
.subckt sky130_fd_sc_hd__mux4_1 A0 A1 A2 A3 S0 S1 VGND VNB VPB VPWR X
.ends

* Black-box entry subcircuit for sky130_fd_sc_hd__o21a_1 abstract view
.subckt sky130_fd_sc_hd__o21a_1 A1 A2 B1 VGND VNB VPB VPWR X
.ends

* Black-box entry subcircuit for sky130_fd_sc_hd__fill_1 abstract view
.subckt sky130_fd_sc_hd__fill_1 VGND VNB VPB VPWR
.ends

* Black-box entry subcircuit for sky130_ef_sc_hd__decap_12 abstract view
.subckt sky130_ef_sc_hd__decap_12 VPWR VGND VPB VNB
.ends

* Black-box entry subcircuit for sky130_fd_sc_hd__decap_6 abstract view
.subckt sky130_fd_sc_hd__decap_6 VGND VNB VPB VPWR
.ends

* Black-box entry subcircuit for sky130_fd_sc_hd__dfxtp_1 abstract view
.subckt sky130_fd_sc_hd__dfxtp_1 CLK D VGND VNB VPB VPWR Q
.ends

* Black-box entry subcircuit for sky130_fd_sc_hd__dlygate4sd3_1 abstract view
.subckt sky130_fd_sc_hd__dlygate4sd3_1 A VGND VNB VPB VPWR X
.ends

* Black-box entry subcircuit for sky130_fd_sc_hd__buf_2 abstract view
.subckt sky130_fd_sc_hd__buf_2 A VGND VNB VPB VPWR X
.ends

* Black-box entry subcircuit for sky130_fd_sc_hd__clkbuf_16 abstract view
.subckt sky130_fd_sc_hd__clkbuf_16 A VGND VNB VPB VPWR X
.ends

* Black-box entry subcircuit for sky130_fd_sc_hd__a22o_1 abstract view
.subckt sky130_fd_sc_hd__a22o_1 A1 A2 B1 B2 VGND VNB VPB VPWR X
.ends

* Black-box entry subcircuit for sky130_fd_sc_hd__and2b_1 abstract view
.subckt sky130_fd_sc_hd__and2b_1 A_N B VGND VNB VPB VPWR X
.ends

* Black-box entry subcircuit for sky130_fd_sc_hd__and4b_1 abstract view
.subckt sky130_fd_sc_hd__and4b_1 A_N B C D VGND VNB VPB VPWR X
.ends

* Black-box entry subcircuit for sky130_fd_sc_hd__clkbuf_4 abstract view
.subckt sky130_fd_sc_hd__clkbuf_4 A VGND VNB VPB VPWR X
.ends

* Black-box entry subcircuit for sky130_fd_sc_hd__clkbuf_2 abstract view
.subckt sky130_fd_sc_hd__clkbuf_2 A VGND VNB VPB VPWR X
.ends

* Black-box entry subcircuit for sky130_fd_sc_hd__clkinv_2 abstract view
.subckt sky130_fd_sc_hd__clkinv_2 A VGND VNB VPB VPWR Y
.ends

* Black-box entry subcircuit for sky130_fd_sc_hd__or3_1 abstract view
.subckt sky130_fd_sc_hd__or3_1 A B C VGND VNB VPB VPWR X
.ends

* Black-box entry subcircuit for sky130_fd_sc_hd__buf_4 abstract view
.subckt sky130_fd_sc_hd__buf_4 A VGND VNB VPB VPWR X
.ends

* Black-box entry subcircuit for sky130_fd_sc_hd__nor2_1 abstract view
.subckt sky130_fd_sc_hd__nor2_1 A B VGND VNB VPB VPWR Y
.ends

* Black-box entry subcircuit for sky130_fd_sc_hd__bufinv_16 abstract view
.subckt sky130_fd_sc_hd__bufinv_16 A VGND VNB VPB VPWR Y
.ends

* Black-box entry subcircuit for sky130_fd_sc_hd__clkinvlp_4 abstract view
.subckt sky130_fd_sc_hd__clkinvlp_4 A VGND VNB VPB VPWR Y
.ends

* Black-box entry subcircuit for sky130_fd_sc_hd__buf_1 abstract view
.subckt sky130_fd_sc_hd__buf_1 A VGND VNB VPB VPWR X
.ends

* Black-box entry subcircuit for sky130_fd_sc_hd__dlymetal6s2s_1 abstract view
.subckt sky130_fd_sc_hd__dlymetal6s2s_1 A VGND VNB VPB VPWR X
.ends

* Black-box entry subcircuit for sky130_fd_sc_hd__clkbuf_1 abstract view
.subckt sky130_fd_sc_hd__clkbuf_1 A VGND VNB VPB VPWR X
.ends

* Black-box entry subcircuit for sky130_fd_sc_hd__and4bb_1 abstract view
.subckt sky130_fd_sc_hd__and4bb_1 A_N B_N C D VGND VNB VPB VPWR X
.ends

* Black-box entry subcircuit for sky130_fd_sc_hd__and4_1 abstract view
.subckt sky130_fd_sc_hd__and4_1 A B C D VGND VNB VPB VPWR X
.ends

.subckt Register_file A1[0] A1[1] A1[2] A2[0] A2[1] A2[2] A3[0] A3[1] A3[2] RD1[0]
+ RD1[10] RD1[11] RD1[12] RD1[13] RD1[14] RD1[15] RD1[1] RD1[2] RD1[3] RD1[4] RD1[5]
+ RD1[6] RD1[7] RD1[8] RD1[9] RD2[0] RD2[10] RD2[11] RD2[12] RD2[13] RD2[14] RD2[15]
+ RD2[1] RD2[2] RD2[3] RD2[4] RD2[5] RD2[6] RD2[7] RD2[8] RD2[9] RegWrite VGND VPWR
+ WD3[0] WD3[10] WD3[11] WD3[12] WD3[13] WD3[14] WD3[15] WD3[1] WD3[2] WD3[3] WD3[4]
+ WD3[5] WD3[6] WD3[7] WD3[8] WD3[9] clk
X_501_ net133 net13 net64 VGND VGND VPWR VPWR _067_ sky130_fd_sc_hd__mux2_1
XFILLER_13_166 VGND VGND VPWR VPWR sky130_fd_sc_hd__fill_2
XFILLER_13_122 VGND VGND VPWR VPWR sky130_fd_sc_hd__decap_3
X_432_ net142 net12 net71 VGND VGND VPWR VPWR _002_ sky130_fd_sc_hd__mux2_1
X_294_ reg_array\[1\]\[7\] net83 VGND VGND VPWR VPWR _145_ sky130_fd_sc_hd__and2_1
XFILLER_3_89 VGND VGND VPWR VPWR sky130_fd_sc_hd__decap_8
X_363_ reg_array\[2\]\[4\] reg_array\[3\]\[4\] net91 VGND VGND VPWR VPWR _201_ sky130_fd_sc_hd__mux2_1
XTAP_TAPCELL_ROW_37_231 VGND VPWR sky130_fd_sc_hd__tapvpwrvgnd_1
XTAP_TAPCELL_ROW_6_107 VGND VPWR sky130_fd_sc_hd__tapvpwrvgnd_1
XFILLER_37_51 VGND VGND VPWR VPWR sky130_fd_sc_hd__decap_4
X_346_ reg_array\[4\]\[1\] reg_array\[5\]\[1\] reg_array\[6\]\[1\] reg_array\[7\]\[1\]
+ net91 net87 VGND VGND VPWR VPWR _187_ sky130_fd_sc_hd__mux4_1
XTAP_TAPCELL_ROW_20_164 VGND VPWR sky130_fd_sc_hd__tapvpwrvgnd_1
X_415_ _240_ _242_ net75 VGND VGND VPWR VPWR net48 sky130_fd_sc_hd__o21a_1
XFILLER_24_206 VGND VGND VPWR VPWR sky130_fd_sc_hd__fill_2
X_277_ _129_ _131_ net81 VGND VGND VPWR VPWR net36 sky130_fd_sc_hd__o21a_1
XFILLER_5_195 VGND VGND VPWR VPWR sky130_fd_sc_hd__fill_1
X_329_ reg_array\[1\]\[14\] net83 VGND VGND VPWR VPWR _173_ sky130_fd_sc_hd__and2_1
XFILLER_2_176 VGND VGND VPWR VPWR sky130_fd_sc_hd__decap_8
XPHY_EDGE_ROW_8_Left_47 VGND VGND VPWR VPWR sky130_fd_sc_hd__decap_3
XFILLER_38_139 VGND VGND VPWR VPWR sky130_fd_sc_hd__fill_1
XFILLER_34_85 VPWR VGND VPWR VGND sky130_ef_sc_hd__decap_12
XFILLER_22_7 VPWR VGND VPWR VGND sky130_ef_sc_hd__decap_12
XFILLER_37_161 VGND VGND VPWR VPWR sky130_fd_sc_hd__decap_6
XFILLER_29_106 VGND VGND VPWR VPWR sky130_fd_sc_hd__decap_6
X_594_ clknet_3_2__leaf_clk _046_ VGND VGND VPWR VPWR reg_array\[1\]\[6\] sky130_fd_sc_hd__dfxtp_1
Xhold85 reg_array\[3\]\[14\] VGND VGND VPWR VPWR net185 sky130_fd_sc_hd__dlygate4sd3_1
Xhold30 reg_array\[5\]\[14\] VGND VGND VPWR VPWR net130 sky130_fd_sc_hd__dlygate4sd3_1
Xhold63 reg_array\[7\]\[3\] VGND VGND VPWR VPWR net163 sky130_fd_sc_hd__dlygate4sd3_1
Xhold96 reg_array\[5\]\[2\] VGND VGND VPWR VPWR net196 sky130_fd_sc_hd__dlygate4sd3_1
Xhold74 reg_array\[6\]\[10\] VGND VGND VPWR VPWR net174 sky130_fd_sc_hd__dlygate4sd3_1
XFILLER_4_205 VGND VGND VPWR VPWR sky130_fd_sc_hd__fill_2
Xhold41 reg_array\[6\]\[4\] VGND VGND VPWR VPWR net141 sky130_fd_sc_hd__dlygate4sd3_1
Xhold52 reg_array\[2\]\[5\] VGND VGND VPWR VPWR net152 sky130_fd_sc_hd__dlygate4sd3_1
XFILLER_34_197 VGND VGND VPWR VPWR sky130_fd_sc_hd__decap_8
XFILLER_19_161 VGND VGND VPWR VPWR sky130_fd_sc_hd__decap_6
XFILLER_13_3 VPWR VGND VPWR VGND sky130_ef_sc_hd__decap_12
XFILLER_31_53 VGND VGND VPWR VPWR sky130_fd_sc_hd__decap_3
Xoutput31 net31 VGND VGND VPWR VPWR RD1[13] sky130_fd_sc_hd__buf_2
Xoutput42 net42 VGND VGND VPWR VPWR RD1[9] sky130_fd_sc_hd__buf_2
XFILLER_31_167 VGND VGND VPWR VPWR sky130_fd_sc_hd__fill_1
X_646_ clknet_3_4__leaf_clk _098_ VGND VGND VPWR VPWR reg_array\[7\]\[10\] sky130_fd_sc_hd__dfxtp_1
Xoutput53 net53 VGND VGND VPWR VPWR RD2[4] sky130_fd_sc_hd__buf_2
X_577_ clknet_3_0__leaf_clk _029_ VGND VGND VPWR VPWR reg_array\[2\]\[5\] sky130_fd_sc_hd__dfxtp_1
XPHY_EDGE_ROW_37_Left_76 VGND VGND VPWR VPWR sky130_fd_sc_hd__decap_3
X_431_ net128 net26 net71 VGND VGND VPWR VPWR _001_ sky130_fd_sc_hd__mux2_1
Xclkbuf_3_6__f_clk clknet_0_clk VGND VGND VPWR VPWR clknet_3_6__leaf_clk sky130_fd_sc_hd__clkbuf_16
X_500_ net174 net12 net64 VGND VGND VPWR VPWR _066_ sky130_fd_sc_hd__mux2_1
X_362_ reg_array\[1\]\[4\] net77 VGND VGND VPWR VPWR _200_ sky130_fd_sc_hd__and2_1
XFILLER_3_57 VGND VGND VPWR VPWR sky130_fd_sc_hd__decap_8
X_293_ reg_array\[4\]\[7\] reg_array\[5\]\[7\] reg_array\[6\]\[7\] reg_array\[7\]\[7\]
+ net97 net96 VGND VGND VPWR VPWR _144_ sky130_fd_sc_hd__mux4_1
X_629_ clknet_3_2__leaf_clk _081_ VGND VGND VPWR VPWR reg_array\[5\]\[9\] sky130_fd_sc_hd__dfxtp_1
XTAP_TAPCELL_ROW_14_140 VGND VPWR sky130_fd_sc_hd__tapvpwrvgnd_1
XTAP_TAPCELL_ROW_6_108 VGND VPWR sky130_fd_sc_hd__tapvpwrvgnd_1
XTAP_TAPCELL_ROW_37_232 VGND VPWR sky130_fd_sc_hd__tapvpwrvgnd_1
XTAP_TAPCELL_ROW_20_165 VGND VPWR sky130_fd_sc_hd__tapvpwrvgnd_1
XFILLER_10_137 VGND VGND VPWR VPWR sky130_fd_sc_hd__decap_3
X_414_ net86 _239_ _241_ net74 VGND VGND VPWR VPWR _242_ sky130_fd_sc_hd__a22o_1
X_276_ net93 _128_ _130_ net79 VGND VGND VPWR VPWR _131_ sky130_fd_sc_hd__a22o_1
X_345_ _183_ _186_ net75 VGND VGND VPWR VPWR net43 sky130_fd_sc_hd__o21a_1
XPHY_EDGE_ROW_21_Right_21 VGND VGND VPWR VPWR sky130_fd_sc_hd__decap_3
XPHY_EDGE_ROW_12_Right_12 VGND VGND VPWR VPWR sky130_fd_sc_hd__decap_3
XPHY_EDGE_ROW_30_Right_30 VGND VGND VPWR VPWR sky130_fd_sc_hd__decap_3
X_328_ reg_array\[4\]\[14\] reg_array\[5\]\[14\] reg_array\[6\]\[14\] reg_array\[7\]\[14\]
+ net99 net95 VGND VGND VPWR VPWR _172_ sky130_fd_sc_hd__mux4_1
X_259_ reg_array\[4\]\[0\] reg_array\[5\]\[0\] net99 VGND VGND VPWR VPWR _117_ sky130_fd_sc_hd__mux2_1
XPHY_EDGE_ROW_24_Left_63 VGND VGND VPWR VPWR sky130_fd_sc_hd__decap_3
XFILLER_34_97 VGND VGND VPWR VPWR sky130_fd_sc_hd__decap_6
Xhold97 reg_array\[3\]\[8\] VGND VGND VPWR VPWR net197 sky130_fd_sc_hd__dlygate4sd3_1
Xhold64 reg_array\[7\]\[1\] VGND VGND VPWR VPWR net164 sky130_fd_sc_hd__dlygate4sd3_1
Xhold86 reg_array\[7\]\[12\] VGND VGND VPWR VPWR net186 sky130_fd_sc_hd__dlygate4sd3_1
Xhold53 reg_array\[4\]\[15\] VGND VGND VPWR VPWR net153 sky130_fd_sc_hd__dlygate4sd3_1
Xhold75 reg_array\[6\]\[7\] VGND VGND VPWR VPWR net175 sky130_fd_sc_hd__dlygate4sd3_1
Xhold42 reg_array\[4\]\[10\] VGND VGND VPWR VPWR net142 sky130_fd_sc_hd__dlygate4sd3_1
Xhold20 reg_array\[2\]\[7\] VGND VGND VPWR VPWR net120 sky130_fd_sc_hd__dlygate4sd3_1
Xhold31 reg_array\[7\]\[0\] VGND VGND VPWR VPWR net131 sky130_fd_sc_hd__dlygate4sd3_1
XFILLER_4_228 VGND VGND VPWR VPWR sky130_fd_sc_hd__fill_1
XFILLER_34_110 VPWR VGND VPWR VGND sky130_ef_sc_hd__decap_12
X_593_ clknet_3_0__leaf_clk _045_ VGND VGND VPWR VPWR reg_array\[1\]\[5\] sky130_fd_sc_hd__dfxtp_1
XPHY_EDGE_ROW_11_Left_50 VGND VGND VPWR VPWR sky130_fd_sc_hd__decap_3
XPHY_EDGE_ROW_6_Right_6 VGND VGND VPWR VPWR sky130_fd_sc_hd__decap_3
XFILLER_31_113 VGND VGND VPWR VPWR sky130_fd_sc_hd__decap_4
X_645_ clknet_3_2__leaf_clk _097_ VGND VGND VPWR VPWR reg_array\[7\]\[9\] sky130_fd_sc_hd__dfxtp_1
Xoutput32 net32 VGND VGND VPWR VPWR RD1[14] sky130_fd_sc_hd__buf_2
Xoutput54 net54 VGND VGND VPWR VPWR RD2[5] sky130_fd_sc_hd__buf_2
X_576_ clknet_3_4__leaf_clk _028_ VGND VGND VPWR VPWR reg_array\[2\]\[4\] sky130_fd_sc_hd__dfxtp_1
Xoutput43 net43 VGND VGND VPWR VPWR RD2[0] sky130_fd_sc_hd__buf_2
X_430_ net179 net25 net72 VGND VGND VPWR VPWR _000_ sky130_fd_sc_hd__mux2_1
X_292_ _141_ _143_ net81 VGND VGND VPWR VPWR net39 sky130_fd_sc_hd__o21a_1
XTAP_TAPCELL_ROW_23_174 VGND VPWR sky130_fd_sc_hd__tapvpwrvgnd_1
X_361_ reg_array\[4\]\[4\] reg_array\[5\]\[4\] reg_array\[6\]\[4\] reg_array\[7\]\[4\]
+ net91 net87 VGND VGND VPWR VPWR _199_ sky130_fd_sc_hd__mux4_1
X_628_ clknet_3_7__leaf_clk _080_ VGND VGND VPWR VPWR reg_array\[5\]\[8\] sky130_fd_sc_hd__dfxtp_1
X_559_ clknet_3_0__leaf_clk _011_ VGND VGND VPWR VPWR reg_array\[3\]\[3\] sky130_fd_sc_hd__dfxtp_1
XTAP_TAPCELL_ROW_14_141 VGND VPWR sky130_fd_sc_hd__tapvpwrvgnd_1
XFILLER_12_190 VGND VGND VPWR VPWR sky130_fd_sc_hd__decap_6
XTAP_TAPCELL_ROW_6_109 VGND VPWR sky130_fd_sc_hd__tapvpwrvgnd_1
XTAP_TAPCELL_ROW_37_233 VGND VPWR sky130_fd_sc_hd__tapvpwrvgnd_1
X_275_ reg_array\[2\]\[3\] reg_array\[3\]\[3\] net97 VGND VGND VPWR VPWR _130_ sky130_fd_sc_hd__mux2_1
X_413_ reg_array\[2\]\[14\] reg_array\[3\]\[14\] net91 VGND VGND VPWR VPWR _241_ sky130_fd_sc_hd__mux2_1
X_344_ net86 _182_ net74 _185_ VGND VGND VPWR VPWR _186_ sky130_fd_sc_hd__a22o_1
XTAP_TAPCELL_ROW_31_206 VGND VPWR sky130_fd_sc_hd__tapvpwrvgnd_1
XFILLER_23_55 VGND VGND VPWR VPWR sky130_fd_sc_hd__fill_1
XFILLER_0_15 VGND VGND VPWR VPWR sky130_fd_sc_hd__decap_8
XFILLER_3_3 VPWR VGND VPWR VGND sky130_ef_sc_hd__decap_12
XFILLER_36_3 VPWR VGND VPWR VGND sky130_ef_sc_hd__decap_12
X_327_ _169_ _171_ net82 VGND VGND VPWR VPWR net31 sky130_fd_sc_hd__o21a_1
XTAP_TAPCELL_ROW_0_80 VGND VPWR sky130_fd_sc_hd__tapvpwrvgnd_1
X_258_ net95 net93 VGND VGND VPWR VPWR _116_ sky130_fd_sc_hd__and2b_1
XFILLER_9_57 VGND VGND VPWR VPWR sky130_fd_sc_hd__decap_3
XFILLER_38_119 VPWR VGND VPWR VGND sky130_ef_sc_hd__decap_12
XFILLER_20_89 VGND VGND VPWR VPWR sky130_fd_sc_hd__decap_4
Xhold21 reg_array\[6\]\[8\] VGND VGND VPWR VPWR net121 sky130_fd_sc_hd__dlygate4sd3_1
Xhold98 reg_array\[3\]\[12\] VGND VGND VPWR VPWR net198 sky130_fd_sc_hd__dlygate4sd3_1
XFILLER_29_87 VGND VGND VPWR VPWR sky130_fd_sc_hd__fill_2
XFILLER_20_6 VGND VGND VPWR VPWR sky130_fd_sc_hd__decap_4
Xhold43 reg_array\[4\]\[14\] VGND VGND VPWR VPWR net143 sky130_fd_sc_hd__dlygate4sd3_1
Xhold65 reg_array\[7\]\[14\] VGND VGND VPWR VPWR net165 sky130_fd_sc_hd__dlygate4sd3_1
Xhold32 reg_array\[5\]\[7\] VGND VGND VPWR VPWR net132 sky130_fd_sc_hd__dlygate4sd3_1
Xhold54 reg_array\[4\]\[7\] VGND VGND VPWR VPWR net154 sky130_fd_sc_hd__dlygate4sd3_1
X_592_ clknet_3_4__leaf_clk _044_ VGND VGND VPWR VPWR reg_array\[1\]\[4\] sky130_fd_sc_hd__dfxtp_1
Xhold87 reg_array\[3\]\[5\] VGND VGND VPWR VPWR net187 sky130_fd_sc_hd__dlygate4sd3_1
Xhold10 reg_array\[1\]\[2\] VGND VGND VPWR VPWR net110 sky130_fd_sc_hd__dlygate4sd3_1
Xhold76 reg_array\[4\]\[0\] VGND VGND VPWR VPWR net176 sky130_fd_sc_hd__dlygate4sd3_1
XFILLER_34_122 VGND VGND VPWR VPWR sky130_fd_sc_hd__decap_8
XFILLER_19_185 VGND VGND VPWR VPWR sky130_fd_sc_hd__fill_2
XFILLER_19_141 VGND VGND VPWR VPWR sky130_fd_sc_hd__decap_3
X_644_ clknet_3_6__leaf_clk _096_ VGND VGND VPWR VPWR reg_array\[7\]\[8\] sky130_fd_sc_hd__dfxtp_1
Xoutput55 net55 VGND VGND VPWR VPWR RD2[6] sky130_fd_sc_hd__buf_2
XFILLER_25_177 VGND VGND VPWR VPWR sky130_fd_sc_hd__decap_6
Xoutput33 net33 VGND VGND VPWR VPWR RD1[15] sky130_fd_sc_hd__buf_2
X_575_ clknet_3_2__leaf_clk _027_ VGND VGND VPWR VPWR reg_array\[2\]\[3\] sky130_fd_sc_hd__dfxtp_1
XFILLER_16_111 VGND VGND VPWR VPWR sky130_fd_sc_hd__fill_2
Xoutput44 net44 VGND VGND VPWR VPWR RD2[10] sky130_fd_sc_hd__buf_2
XFILLER_0_221 VGND VGND VPWR VPWR sky130_fd_sc_hd__decap_3
XTAP_TAPCELL_ROW_17_150 VGND VPWR sky130_fd_sc_hd__tapvpwrvgnd_1
X_291_ net94 _140_ _142_ net80 VGND VGND VPWR VPWR _143_ sky130_fd_sc_hd__a22o_1
XTAP_TAPCELL_ROW_23_175 VGND VPWR sky130_fd_sc_hd__tapvpwrvgnd_1
X_360_ _196_ _198_ net75 VGND VGND VPWR VPWR net52 sky130_fd_sc_hd__o21a_1
XTAP_TAPCELL_ROW_9_118 VGND VPWR sky130_fd_sc_hd__tapvpwrvgnd_1
X_489_ net7 net9 net8 net10 VGND VGND VPWR VPWR _251_ sky130_fd_sc_hd__and4b_1
X_627_ clknet_3_1__leaf_clk _079_ VGND VGND VPWR VPWR reg_array\[5\]\[7\] sky130_fd_sc_hd__dfxtp_1
XFILLER_3_15 VPWR VGND VPWR VGND sky130_ef_sc_hd__decap_12
X_558_ clknet_3_1__leaf_clk _010_ VGND VGND VPWR VPWR reg_array\[3\]\[2\] sky130_fd_sc_hd__dfxtp_1
XFILLER_8_195 VGND VGND VPWR VPWR sky130_fd_sc_hd__fill_1
XFILLER_10_117 VGND VGND VPWR VPWR sky130_fd_sc_hd__decap_4
X_412_ reg_array\[1\]\[14\] net77 VGND VGND VPWR VPWR _240_ sky130_fd_sc_hd__and2_1
XFILLER_18_228 VGND VGND VPWR VPWR sky130_fd_sc_hd__fill_1
X_274_ reg_array\[1\]\[3\] net83 VGND VGND VPWR VPWR _129_ sky130_fd_sc_hd__and2_1
X_343_ reg_array\[2\]\[0\] reg_array\[3\]\[0\] net91 VGND VGND VPWR VPWR _185_ sky130_fd_sc_hd__mux2_1
XFILLER_15_209 VGND VGND VPWR VPWR sky130_fd_sc_hd__decap_4
XFILLER_2_102 VPWR VGND VPWR VGND sky130_ef_sc_hd__decap_12
Xfanout90 net4 VGND VGND VPWR VPWR net90 sky130_fd_sc_hd__buf_2
X_326_ net94 _168_ _170_ net80 VGND VGND VPWR VPWR _171_ sky130_fd_sc_hd__a22o_1
XTAP_TAPCELL_ROW_31_207 VGND VPWR sky130_fd_sc_hd__tapvpwrvgnd_1
XTAP_TAPCELL_ROW_0_81 VGND VPWR sky130_fd_sc_hd__tapvpwrvgnd_1
X_257_ reg_array\[1\]\[0\] net83 VGND VGND VPWR VPWR _115_ sky130_fd_sc_hd__and2_1
XFILLER_9_36 VGND VGND VPWR VPWR sky130_fd_sc_hd__decap_4
XFILLER_18_45 VGND VGND VPWR VPWR sky130_fd_sc_hd__fill_1
XFILLER_11_201 VGND VGND VPWR VPWR sky130_fd_sc_hd__fill_1
X_309_ reg_array\[1\]\[10\] net83 VGND VGND VPWR VPWR _157_ sky130_fd_sc_hd__and2_1
Xhold22 reg_array\[1\]\[9\] VGND VGND VPWR VPWR net122 sky130_fd_sc_hd__dlygate4sd3_1
Xhold66 reg_array\[2\]\[12\] VGND VGND VPWR VPWR net166 sky130_fd_sc_hd__dlygate4sd3_1
XFILLER_29_11 VGND VGND VPWR VPWR sky130_fd_sc_hd__decap_6
XFILLER_28_197 VGND VGND VPWR VPWR sky130_fd_sc_hd__decap_6
Xhold11 reg_array\[7\]\[6\] VGND VGND VPWR VPWR net111 sky130_fd_sc_hd__dlygate4sd3_1
Xhold99 reg_array\[6\]\[13\] VGND VGND VPWR VPWR net199 sky130_fd_sc_hd__dlygate4sd3_1
Xhold88 reg_array\[4\]\[6\] VGND VGND VPWR VPWR net188 sky130_fd_sc_hd__dlygate4sd3_1
Xhold33 reg_array\[6\]\[11\] VGND VGND VPWR VPWR net133 sky130_fd_sc_hd__dlygate4sd3_1
Xhold55 reg_array\[4\]\[11\] VGND VGND VPWR VPWR net155 sky130_fd_sc_hd__dlygate4sd3_1
Xhold77 reg_array\[5\]\[11\] VGND VGND VPWR VPWR net177 sky130_fd_sc_hd__dlygate4sd3_1
X_591_ clknet_3_0__leaf_clk _043_ VGND VGND VPWR VPWR reg_array\[1\]\[3\] sky130_fd_sc_hd__dfxtp_1
Xhold44 reg_array\[2\]\[4\] VGND VGND VPWR VPWR net144 sky130_fd_sc_hd__dlygate4sd3_1
XFILLER_34_156 VPWR VGND VPWR VGND sky130_ef_sc_hd__decap_12
XFILLER_34_145 VGND VGND VPWR VPWR sky130_fd_sc_hd__fill_1
Xoutput34 net34 VGND VGND VPWR VPWR RD1[1] sky130_fd_sc_hd__buf_2
XFILLER_25_167 VGND VGND VPWR VPWR sky130_fd_sc_hd__fill_1
Xoutput45 net45 VGND VGND VPWR VPWR RD2[11] sky130_fd_sc_hd__buf_2
Xoutput56 net56 VGND VGND VPWR VPWR RD2[7] sky130_fd_sc_hd__buf_2
XFILLER_16_178 VGND VGND VPWR VPWR sky130_fd_sc_hd__fill_1
XFILLER_16_123 VGND VGND VPWR VPWR sky130_fd_sc_hd__fill_1
XFILLER_16_101 VGND VGND VPWR VPWR sky130_fd_sc_hd__decap_6
XFILLER_11_3 VGND VGND VPWR VPWR sky130_fd_sc_hd__decap_8
X_574_ clknet_3_1__leaf_clk _026_ VGND VGND VPWR VPWR reg_array\[2\]\[2\] sky130_fd_sc_hd__dfxtp_1
X_643_ clknet_3_0__leaf_clk _095_ VGND VGND VPWR VPWR reg_array\[7\]\[7\] sky130_fd_sc_hd__dfxtp_1
XFILLER_30_192 VGND VGND VPWR VPWR sky130_fd_sc_hd__decap_4
XTAP_TAPCELL_ROW_17_151 VGND VPWR sky130_fd_sc_hd__tapvpwrvgnd_1
XTAP_TAPCELL_ROW_9_119 VGND VPWR sky130_fd_sc_hd__tapvpwrvgnd_1
X_626_ clknet_3_2__leaf_clk _078_ VGND VGND VPWR VPWR reg_array\[5\]\[6\] sky130_fd_sc_hd__dfxtp_1
X_557_ clknet_3_7__leaf_clk _009_ VGND VGND VPWR VPWR reg_array\[3\]\[1\] sky130_fd_sc_hd__dfxtp_1
X_290_ reg_array\[2\]\[6\] reg_array\[3\]\[6\] net97 VGND VGND VPWR VPWR _142_ sky130_fd_sc_hd__mux2_1
XTAP_TAPCELL_ROW_23_176 VGND VPWR sky130_fd_sc_hd__tapvpwrvgnd_1
X_488_ net113 net17 net66 VGND VGND VPWR VPWR _055_ sky130_fd_sc_hd__mux2_1
XFILLER_3_27 VPWR VGND VPWR VGND sky130_ef_sc_hd__decap_12
XFILLER_9_108 VGND VGND VPWR VPWR sky130_fd_sc_hd__decap_4
XFILLER_37_99 VGND VGND VPWR VPWR sky130_fd_sc_hd__fill_2
XFILLER_37_55 VGND VGND VPWR VPWR sky130_fd_sc_hd__fill_1
X_411_ reg_array\[4\]\[14\] reg_array\[5\]\[14\] reg_array\[6\]\[14\] reg_array\[7\]\[14\]
+ net91 net87 VGND VGND VPWR VPWR _239_ sky130_fd_sc_hd__mux4_1
X_342_ net85 net87 VGND VGND VPWR VPWR _184_ sky130_fd_sc_hd__and2b_1
X_273_ reg_array\[4\]\[3\] reg_array\[5\]\[3\] reg_array\[6\]\[3\] reg_array\[7\]\[3\]
+ net97 net96 VGND VGND VPWR VPWR _128_ sky130_fd_sc_hd__mux4_1
XFILLER_5_111 VGND VGND VPWR VPWR sky130_fd_sc_hd__fill_1
X_609_ clknet_3_0__leaf_clk _061_ VGND VGND VPWR VPWR reg_array\[6\]\[5\] sky130_fd_sc_hd__dfxtp_1
XFILLER_23_221 VGND VGND VPWR VPWR sky130_fd_sc_hd__decap_3
XFILLER_2_114 VPWR VGND VPWR VGND sky130_ef_sc_hd__decap_12
X_325_ reg_array\[2\]\[13\] reg_array\[3\]\[13\] net98 VGND VGND VPWR VPWR _170_ sky130_fd_sc_hd__mux2_1
XTAP_TAPCELL_ROW_31_208 VGND VPWR sky130_fd_sc_hd__tapvpwrvgnd_1
Xfanout91 net4 VGND VGND VPWR VPWR net91 sky130_fd_sc_hd__clkbuf_4
Xfanout80 _121_ VGND VGND VPWR VPWR net80 sky130_fd_sc_hd__clkbuf_2
XTAP_TAPCELL_ROW_0_82 VGND VPWR sky130_fd_sc_hd__tapvpwrvgnd_1
X_256_ reg_array\[2\]\[0\] reg_array\[3\]\[0\] reg_array\[6\]\[0\] reg_array\[7\]\[0\]
+ net99 net93 VGND VGND VPWR VPWR _114_ sky130_fd_sc_hd__mux4_1
XFILLER_9_15 VGND VGND VPWR VPWR sky130_fd_sc_hd__decap_4
XPHY_EDGE_ROW_28_Left_67 VGND VGND VPWR VPWR sky130_fd_sc_hd__decap_3
Xclkload0 clknet_3_0__leaf_clk VGND VGND VPWR VPWR clkload0/Y sky130_fd_sc_hd__clkinv_2
X_308_ reg_array\[4\]\[10\] reg_array\[5\]\[10\] reg_array\[6\]\[10\] reg_array\[7\]\[10\]
+ net99 net95 VGND VGND VPWR VPWR _156_ sky130_fd_sc_hd__mux4_1
Xhold23 reg_array\[1\]\[12\] VGND VGND VPWR VPWR net123 sky130_fd_sc_hd__dlygate4sd3_1
Xhold89 reg_array\[5\]\[1\] VGND VGND VPWR VPWR net189 sky130_fd_sc_hd__dlygate4sd3_1
XFILLER_28_110 VGND VGND VPWR VPWR sky130_fd_sc_hd__fill_2
Xhold67 reg_array\[6\]\[6\] VGND VGND VPWR VPWR net167 sky130_fd_sc_hd__dlygate4sd3_1
Xhold12 reg_array\[6\]\[15\] VGND VGND VPWR VPWR net112 sky130_fd_sc_hd__dlygate4sd3_1
Xhold78 reg_array\[2\]\[3\] VGND VGND VPWR VPWR net178 sky130_fd_sc_hd__dlygate4sd3_1
Xhold56 reg_array\[5\]\[5\] VGND VGND VPWR VPWR net156 sky130_fd_sc_hd__dlygate4sd3_1
Xhold45 reg_array\[7\]\[4\] VGND VGND VPWR VPWR net145 sky130_fd_sc_hd__dlygate4sd3_1
X_590_ clknet_3_1__leaf_clk _042_ VGND VGND VPWR VPWR reg_array\[1\]\[2\] sky130_fd_sc_hd__dfxtp_1
Xhold34 reg_array\[6\]\[0\] VGND VGND VPWR VPWR net134 sky130_fd_sc_hd__dlygate4sd3_1
Xoutput46 net46 VGND VGND VPWR VPWR RD2[12] sky130_fd_sc_hd__buf_2
Xoutput57 net57 VGND VGND VPWR VPWR RD2[8] sky130_fd_sc_hd__buf_2
XFILLER_31_57 VGND VGND VPWR VPWR sky130_fd_sc_hd__fill_2
XFILLER_25_157 VGND VGND VPWR VPWR sky130_fd_sc_hd__fill_1
Xoutput35 net35 VGND VGND VPWR VPWR RD1[2] sky130_fd_sc_hd__buf_2
XPHY_EDGE_ROW_28_Right_28 VGND VGND VPWR VPWR sky130_fd_sc_hd__decap_3
X_642_ clknet_3_2__leaf_clk _094_ VGND VGND VPWR VPWR reg_array\[7\]\[6\] sky130_fd_sc_hd__dfxtp_1
X_573_ clknet_3_7__leaf_clk _025_ VGND VGND VPWR VPWR reg_array\[2\]\[1\] sky130_fd_sc_hd__dfxtp_1
XPHY_EDGE_ROW_19_Right_19 VGND VGND VPWR VPWR sky130_fd_sc_hd__decap_3
Xclkbuf_3_1__f_clk clknet_0_clk VGND VGND VPWR VPWR clknet_3_1__leaf_clk sky130_fd_sc_hd__clkbuf_16
XPHY_EDGE_ROW_37_Right_37 VGND VGND VPWR VPWR sky130_fd_sc_hd__decap_3
XFILLER_22_138 VGND VGND VPWR VPWR sky130_fd_sc_hd__fill_2
XTAP_TAPCELL_ROW_17_152 VGND VPWR sky130_fd_sc_hd__tapvpwrvgnd_1
XPHY_EDGE_ROW_15_Left_54 VGND VGND VPWR VPWR sky130_fd_sc_hd__decap_3
XTAP_TAPCELL_ROW_23_177 VGND VPWR sky130_fd_sc_hd__tapvpwrvgnd_1
X_625_ clknet_3_0__leaf_clk _077_ VGND VGND VPWR VPWR reg_array\[5\]\[5\] sky130_fd_sc_hd__dfxtp_1
XFILLER_3_39 VGND VGND VPWR VPWR sky130_fd_sc_hd__decap_4
X_487_ net151 net16 net65 VGND VGND VPWR VPWR _054_ sky130_fd_sc_hd__mux2_1
X_556_ clknet_3_5__leaf_clk _008_ VGND VGND VPWR VPWR reg_array\[3\]\[0\] sky130_fd_sc_hd__dfxtp_1
XFILLER_37_67 VPWR VGND VPWR VGND sky130_ef_sc_hd__decap_12
X_410_ _236_ _238_ net76 VGND VGND VPWR VPWR net47 sky130_fd_sc_hd__o21a_1
XPHY_EDGE_ROW_0_Left_39 VGND VGND VPWR VPWR sky130_fd_sc_hd__decap_3
X_272_ _125_ _127_ net81 VGND VGND VPWR VPWR net35 sky130_fd_sc_hd__o21a_1
X_341_ reg_array\[1\]\[0\] net77 VGND VGND VPWR VPWR _183_ sky130_fd_sc_hd__and2_1
X_539_ net108 net17 net60 VGND VGND VPWR VPWR _103_ sky130_fd_sc_hd__mux2_1
X_608_ clknet_3_4__leaf_clk _060_ VGND VGND VPWR VPWR reg_array\[6\]\[4\] sky130_fd_sc_hd__dfxtp_1
XFILLER_4_82 VGND VGND VPWR VPWR sky130_fd_sc_hd__fill_2
X_324_ reg_array\[1\]\[13\] net84 VGND VGND VPWR VPWR _169_ sky130_fd_sc_hd__and2_1
Xfanout92 net4 VGND VGND VPWR VPWR net92 sky130_fd_sc_hd__buf_2
XTAP_TAPCELL_ROW_31_209 VGND VPWR sky130_fd_sc_hd__tapvpwrvgnd_1
Xfanout70 _248_ VGND VGND VPWR VPWR net70 sky130_fd_sc_hd__buf_2
X_255_ net93 net99 net95 VGND VGND VPWR VPWR _113_ sky130_fd_sc_hd__or3_1
Xfanout81 _113_ VGND VGND VPWR VPWR net81 sky130_fd_sc_hd__clkbuf_4
XFILLER_0_29 VPWR VGND VPWR VGND sky130_ef_sc_hd__decap_12
XFILLER_2_126 VPWR VGND VPWR VGND sky130_ef_sc_hd__decap_12
XFILLER_1_181 VPWR VGND VPWR VGND sky130_ef_sc_hd__decap_12
XTAP_TAPCELL_ROW_0_83 VGND VPWR sky130_fd_sc_hd__tapvpwrvgnd_1
XFILLER_34_57 VPWR VGND VPWR VGND sky130_ef_sc_hd__decap_12
Xclkload1 clknet_3_1__leaf_clk VGND VGND VPWR VPWR clkload1/Y sky130_fd_sc_hd__clkinv_2
XFILLER_11_225 VGND VGND VPWR VPWR sky130_fd_sc_hd__fill_1
XFILLER_1_3 VPWR VGND VPWR VGND sky130_ef_sc_hd__decap_12
XPHY_EDGE_ROW_3_Left_42 VGND VGND VPWR VPWR sky130_fd_sc_hd__decap_3
X_307_ _153_ _155_ net82 VGND VGND VPWR VPWR net42 sky130_fd_sc_hd__o21a_1
Xhold79 reg_array\[4\]\[8\] VGND VGND VPWR VPWR net179 sky130_fd_sc_hd__dlygate4sd3_1
Xhold35 reg_array\[5\]\[6\] VGND VGND VPWR VPWR net135 sky130_fd_sc_hd__dlygate4sd3_1
XFILLER_29_35 VGND VGND VPWR VPWR sky130_fd_sc_hd__decap_3
Xhold13 reg_array\[1\]\[15\] VGND VGND VPWR VPWR net113 sky130_fd_sc_hd__dlygate4sd3_1
Xhold24 reg_array\[2\]\[11\] VGND VGND VPWR VPWR net124 sky130_fd_sc_hd__dlygate4sd3_1
Xhold68 reg_array\[7\]\[11\] VGND VGND VPWR VPWR net168 sky130_fd_sc_hd__dlygate4sd3_1
Xhold57 reg_array\[6\]\[14\] VGND VGND VPWR VPWR net157 sky130_fd_sc_hd__dlygate4sd3_1
Xhold46 reg_array\[7\]\[5\] VGND VGND VPWR VPWR net146 sky130_fd_sc_hd__dlygate4sd3_1
XFILLER_19_133 VGND VGND VPWR VPWR sky130_fd_sc_hd__decap_8
XFILLER_10_81 VGND VGND VPWR VPWR sky130_fd_sc_hd__decap_3
Xoutput47 net47 VGND VGND VPWR VPWR RD2[13] sky130_fd_sc_hd__buf_2
Xoutput58 net58 VGND VGND VPWR VPWR RD2[9] sky130_fd_sc_hd__buf_2
XTAP_TAPCELL_ROW_26_186 VGND VPWR sky130_fd_sc_hd__tapvpwrvgnd_1
Xoutput36 net36 VGND VGND VPWR VPWR RD1[3] sky130_fd_sc_hd__buf_2
X_572_ clknet_3_5__leaf_clk _024_ VGND VGND VPWR VPWR reg_array\[2\]\[0\] sky130_fd_sc_hd__dfxtp_1
X_641_ clknet_3_0__leaf_clk _093_ VGND VGND VPWR VPWR reg_array\[7\]\[5\] sky130_fd_sc_hd__dfxtp_1
XTAP_TAPCELL_ROW_17_153 VGND VPWR sky130_fd_sc_hd__tapvpwrvgnd_1
XFILLER_36_209 VPWR VGND VPWR VGND sky130_ef_sc_hd__decap_12
X_486_ net102 net15 net66 VGND VGND VPWR VPWR _053_ sky130_fd_sc_hd__mux2_1
XPHY_EDGE_ROW_32_Left_71 VGND VGND VPWR VPWR sky130_fd_sc_hd__decap_3
X_555_ clknet_3_1__leaf_clk _007_ VGND VGND VPWR VPWR reg_array\[4\]\[15\] sky130_fd_sc_hd__dfxtp_1
XFILLER_16_80 VGND VGND VPWR VPWR sky130_fd_sc_hd__decap_4
XTAP_TAPCELL_ROW_3_94 VGND VPWR sky130_fd_sc_hd__tapvpwrvgnd_1
X_624_ clknet_3_4__leaf_clk _076_ VGND VGND VPWR VPWR reg_array\[5\]\[4\] sky130_fd_sc_hd__dfxtp_1
XFILLER_37_79 VPWR VGND VPWR VGND sky130_ef_sc_hd__decap_12
XFILLER_37_57 VGND VGND VPWR VPWR sky130_fd_sc_hd__decap_4
XFILLER_35_220 VGND VGND VPWR VPWR sky130_fd_sc_hd__decap_4
Xhold110 reg_array\[4\]\[1\] VGND VGND VPWR VPWR net210 sky130_fd_sc_hd__dlygate4sd3_1
XTAP_TAPCELL_ROW_5_102 VGND VPWR sky130_fd_sc_hd__tapvpwrvgnd_1
XTAP_TAPCELL_ROW_34_218 VGND VPWR sky130_fd_sc_hd__tapvpwrvgnd_1
X_538_ net165 net16 net60 VGND VGND VPWR VPWR _102_ sky130_fd_sc_hd__mux2_1
X_607_ clknet_3_0__leaf_clk _059_ VGND VGND VPWR VPWR reg_array\[6\]\[3\] sky130_fd_sc_hd__dfxtp_1
X_271_ net93 _124_ _126_ net79 VGND VGND VPWR VPWR _127_ sky130_fd_sc_hd__a22o_1
XTAP_TAPCELL_ROW_11_126 VGND VPWR sky130_fd_sc_hd__tapvpwrvgnd_1
XFILLER_5_113 VPWR VGND VPWR VGND sky130_ef_sc_hd__decap_12
X_340_ reg_array\[4\]\[0\] reg_array\[5\]\[0\] reg_array\[6\]\[0\] reg_array\[7\]\[0\]
+ net91 net87 VGND VGND VPWR VPWR _182_ sky130_fd_sc_hd__mux4_1
X_469_ net139 net15 net67 VGND VGND VPWR VPWR _037_ sky130_fd_sc_hd__mux2_1
X_323_ reg_array\[4\]\[13\] reg_array\[5\]\[13\] reg_array\[6\]\[13\] reg_array\[7\]\[13\]
+ net98 net96 VGND VGND VPWR VPWR _168_ sky130_fd_sc_hd__mux4_1
Xfanout71 _247_ VGND VGND VPWR VPWR net71 sky130_fd_sc_hd__buf_4
Xfanout60 _253_ VGND VGND VPWR VPWR net60 sky130_fd_sc_hd__buf_2
Xfanout82 _113_ VGND VGND VPWR VPWR net82 sky130_fd_sc_hd__buf_2
X_254_ net93 net96 VGND VGND VPWR VPWR _112_ sky130_fd_sc_hd__nor2_1
XFILLER_2_138 VGND VGND VPWR VPWR sky130_fd_sc_hd__fill_2
Xfanout93 net94 VGND VGND VPWR VPWR net93 sky130_fd_sc_hd__buf_2
XTAP_TAPCELL_ROW_0_84 VGND VPWR sky130_fd_sc_hd__tapvpwrvgnd_1
XFILLER_1_193 VPWR VGND VPWR VGND sky130_ef_sc_hd__decap_12
XFILLER_34_69 VPWR VGND VPWR VGND sky130_ef_sc_hd__decap_12
Xclkload2 clknet_3_2__leaf_clk VGND VGND VPWR VPWR clkload2/Y sky130_fd_sc_hd__bufinv_16
XFILLER_18_26 VGND VGND VPWR VPWR sky130_fd_sc_hd__fill_2
X_306_ net94 _152_ _154_ net80 VGND VGND VPWR VPWR _155_ sky130_fd_sc_hd__a22o_1
XFILLER_37_167 VGND VGND VPWR VPWR sky130_fd_sc_hd__fill_1
Xhold25 reg_array\[7\]\[8\] VGND VGND VPWR VPWR net125 sky130_fd_sc_hd__dlygate4sd3_1
XFILLER_29_47 VGND VGND VPWR VPWR sky130_fd_sc_hd__decap_3
Xhold69 reg_array\[6\]\[1\] VGND VGND VPWR VPWR net169 sky130_fd_sc_hd__dlygate4sd3_1
Xhold47 reg_array\[6\]\[3\] VGND VGND VPWR VPWR net147 sky130_fd_sc_hd__dlygate4sd3_1
Xhold14 reg_array\[1\]\[7\] VGND VGND VPWR VPWR net114 sky130_fd_sc_hd__dlygate4sd3_1
Xhold36 reg_array\[6\]\[5\] VGND VGND VPWR VPWR net136 sky130_fd_sc_hd__dlygate4sd3_1
Xhold58 reg_array\[7\]\[7\] VGND VGND VPWR VPWR net158 sky130_fd_sc_hd__dlygate4sd3_1
XFILLER_19_167 VGND VGND VPWR VPWR sky130_fd_sc_hd__fill_1
XFILLER_10_60 VGND VGND VPWR VPWR sky130_fd_sc_hd__decap_4
XTAP_TAPCELL_ROW_26_187 VGND VPWR sky130_fd_sc_hd__tapvpwrvgnd_1
X_571_ clknet_3_1__leaf_clk _023_ VGND VGND VPWR VPWR reg_array\[3\]\[15\] sky130_fd_sc_hd__dfxtp_1
Xoutput48 net48 VGND VGND VPWR VPWR RD2[14] sky130_fd_sc_hd__buf_2
XPHY_EDGE_ROW_1_Right_1 VGND VGND VPWR VPWR sky130_fd_sc_hd__decap_3
XFILLER_0_225 VGND VGND VPWR VPWR sky130_fd_sc_hd__decap_4
Xoutput37 net37 VGND VGND VPWR VPWR RD1[4] sky130_fd_sc_hd__buf_2
X_640_ clknet_3_4__leaf_clk _092_ VGND VGND VPWR VPWR reg_array\[7\]\[4\] sky130_fd_sc_hd__dfxtp_1
XFILLER_7_50 VGND VGND VPWR VPWR sky130_fd_sc_hd__decap_6
XFILLER_7_72 VPWR VGND VPWR VGND sky130_ef_sc_hd__decap_12
XFILLER_21_162 VGND VGND VPWR VPWR sky130_fd_sc_hd__decap_6
X_485_ net123 net14 net66 VGND VGND VPWR VPWR _052_ sky130_fd_sc_hd__mux2_1
X_554_ clknet_3_5__leaf_clk _006_ VGND VGND VPWR VPWR reg_array\[4\]\[14\] sky130_fd_sc_hd__dfxtp_1
X_623_ clknet_3_0__leaf_clk _075_ VGND VGND VPWR VPWR reg_array\[5\]\[3\] sky130_fd_sc_hd__dfxtp_1
XTAP_TAPCELL_ROW_3_95 VGND VPWR sky130_fd_sc_hd__tapvpwrvgnd_1
Xhold100 reg_array\[4\]\[12\] VGND VGND VPWR VPWR net200 sky130_fd_sc_hd__dlygate4sd3_1
Xhold111 reg_array\[2\]\[6\] VGND VGND VPWR VPWR net211 sky130_fd_sc_hd__dlygate4sd3_1
XTAP_TAPCELL_ROW_5_103 VGND VPWR sky130_fd_sc_hd__tapvpwrvgnd_1
XTAP_TAPCELL_ROW_11_127 VGND VPWR sky130_fd_sc_hd__tapvpwrvgnd_1
XFILLER_5_125 VGND VGND VPWR VPWR sky130_fd_sc_hd__decap_4
X_270_ reg_array\[2\]\[2\] reg_array\[3\]\[2\] net97 VGND VGND VPWR VPWR _126_ sky130_fd_sc_hd__mux2_1
X_468_ net166 net14 net68 VGND VGND VPWR VPWR _036_ sky130_fd_sc_hd__mux2_1
XTAP_TAPCELL_ROW_34_219 VGND VPWR sky130_fd_sc_hd__tapvpwrvgnd_1
XFILLER_32_213 VGND VGND VPWR VPWR sky130_fd_sc_hd__fill_2
X_537_ net160 net15 net59 VGND VGND VPWR VPWR _101_ sky130_fd_sc_hd__mux2_1
XFILLER_23_202 VGND VGND VPWR VPWR sky130_fd_sc_hd__fill_1
X_399_ net86 _227_ _229_ net74 VGND VGND VPWR VPWR _230_ sky130_fd_sc_hd__a22o_1
X_606_ clknet_3_1__leaf_clk _058_ VGND VGND VPWR VPWR reg_array\[6\]\[2\] sky130_fd_sc_hd__dfxtp_1
XFILLER_4_62 VGND VGND VPWR VPWR sky130_fd_sc_hd__decap_4
X_322_ _165_ _167_ net82 VGND VGND VPWR VPWR net30 sky130_fd_sc_hd__o21a_1
XFILLER_23_38 VGND VGND VPWR VPWR sky130_fd_sc_hd__fill_1
XFILLER_23_27 VGND VGND VPWR VPWR sky130_fd_sc_hd__fill_2
Xclkbuf_3_7__f_clk clknet_0_clk VGND VGND VPWR VPWR clknet_3_7__leaf_clk sky130_fd_sc_hd__clkbuf_16
Xfanout72 _247_ VGND VGND VPWR VPWR net72 sky130_fd_sc_hd__buf_2
Xfanout61 _252_ VGND VGND VPWR VPWR net61 sky130_fd_sc_hd__clkbuf_4
Xfanout83 _112_ VGND VGND VPWR VPWR net83 sky130_fd_sc_hd__buf_2
Xfanout94 net3 VGND VGND VPWR VPWR net94 sky130_fd_sc_hd__clkbuf_4
XTAP_TAPCELL_ROW_0_85 VGND VPWR sky130_fd_sc_hd__tapvpwrvgnd_1
XFILLER_34_26 VGND VGND VPWR VPWR sky130_fd_sc_hd__fill_2
Xclkload3 clknet_3_3__leaf_clk VGND VGND VPWR VPWR clkload3/Y sky130_fd_sc_hd__bufinv_16
X_305_ reg_array\[2\]\[9\] reg_array\[3\]\[9\] net98 VGND VGND VPWR VPWR _154_ sky130_fd_sc_hd__mux2_1
XFILLER_24_81 VGND VGND VPWR VPWR sky130_fd_sc_hd__decap_3
XFILLER_37_113 VPWR VGND VPWR VGND sky130_ef_sc_hd__decap_12
Xhold26 reg_array\[1\]\[8\] VGND VGND VPWR VPWR net126 sky130_fd_sc_hd__dlygate4sd3_1
Xhold48 reg_array\[6\]\[12\] VGND VGND VPWR VPWR net148 sky130_fd_sc_hd__dlygate4sd3_1
Xhold15 reg_array\[7\]\[2\] VGND VGND VPWR VPWR net115 sky130_fd_sc_hd__dlygate4sd3_1
Xhold59 reg_array\[5\]\[10\] VGND VGND VPWR VPWR net159 sky130_fd_sc_hd__dlygate4sd3_1
Xhold37 reg_array\[2\]\[2\] VGND VGND VPWR VPWR net137 sky130_fd_sc_hd__dlygate4sd3_1
Xoutput49 net49 VGND VGND VPWR VPWR RD2[15] sky130_fd_sc_hd__buf_2
XFILLER_25_138 VGND VGND VPWR VPWR sky130_fd_sc_hd__decap_3
X_570_ clknet_3_5__leaf_clk _022_ VGND VGND VPWR VPWR reg_array\[3\]\[14\] sky130_fd_sc_hd__dfxtp_1
Xoutput38 net38 VGND VGND VPWR VPWR RD1[5] sky130_fd_sc_hd__buf_2
Xoutput27 net27 VGND VGND VPWR VPWR RD1[0] sky130_fd_sc_hd__buf_2
XTAP_TAPCELL_ROW_26_188 VGND VPWR sky130_fd_sc_hd__tapvpwrvgnd_1
Xclkbuf_0_clk clk VGND VGND VPWR VPWR clknet_0_clk sky130_fd_sc_hd__clkbuf_16
XPHY_EDGE_ROW_24_Right_24 VGND VGND VPWR VPWR sky130_fd_sc_hd__decap_3
XPHY_EDGE_ROW_15_Right_15 VGND VGND VPWR VPWR sky130_fd_sc_hd__decap_3
XFILLER_7_84 VPWR VGND VPWR VGND sky130_ef_sc_hd__decap_12
XPHY_EDGE_ROW_33_Right_33 VGND VGND VPWR VPWR sky130_fd_sc_hd__decap_3
X_553_ clknet_3_3__leaf_clk _005_ VGND VGND VPWR VPWR reg_array\[4\]\[13\] sky130_fd_sc_hd__dfxtp_1
X_484_ net118 net13 net66 VGND VGND VPWR VPWR _051_ sky130_fd_sc_hd__mux2_1
X_622_ clknet_3_1__leaf_clk _074_ VGND VGND VPWR VPWR reg_array\[5\]\[2\] sky130_fd_sc_hd__dfxtp_1
Xhold112 reg_array\[3\]\[6\] VGND VGND VPWR VPWR net212 sky130_fd_sc_hd__dlygate4sd3_1
XPHY_EDGE_ROW_19_Left_58 VGND VGND VPWR VPWR sky130_fd_sc_hd__decap_3
Xhold101 reg_array\[3\]\[3\] VGND VGND VPWR VPWR net201 sky130_fd_sc_hd__dlygate4sd3_1
XFILLER_12_29 VGND VGND VPWR VPWR sky130_fd_sc_hd__fill_2
XTAP_TAPCELL_ROW_3_96 VGND VPWR sky130_fd_sc_hd__tapvpwrvgnd_1
XFILLER_37_15 VPWR VGND VPWR VGND sky130_ef_sc_hd__decap_12
XTAP_TAPCELL_ROW_11_128 VGND VPWR sky130_fd_sc_hd__tapvpwrvgnd_1
XTAP_TAPCELL_ROW_5_104 VGND VPWR sky130_fd_sc_hd__tapvpwrvgnd_1
X_536_ net186 net14 net60 VGND VGND VPWR VPWR _100_ sky130_fd_sc_hd__mux2_1
XFILLER_27_81 VGND VGND VPWR VPWR sky130_fd_sc_hd__decap_6
X_605_ clknet_3_6__leaf_clk _057_ VGND VGND VPWR VPWR reg_array\[6\]\[1\] sky130_fd_sc_hd__dfxtp_1
X_398_ reg_array\[2\]\[11\] reg_array\[3\]\[11\] net92 VGND VGND VPWR VPWR _229_ sky130_fd_sc_hd__mux2_1
X_467_ net124 net13 net68 VGND VGND VPWR VPWR _035_ sky130_fd_sc_hd__mux2_1
XFILLER_23_225 VGND VGND VPWR VPWR sky130_fd_sc_hd__decap_4
Xfanout62 _252_ VGND VGND VPWR VPWR net62 sky130_fd_sc_hd__buf_2
Xfanout95 net96 VGND VGND VPWR VPWR net95 sky130_fd_sc_hd__buf_2
X_321_ net94 _164_ _166_ net80 VGND VGND VPWR VPWR _167_ sky130_fd_sc_hd__a22o_1
Xfanout84 _112_ VGND VGND VPWR VPWR net84 sky130_fd_sc_hd__clkbuf_2
Xfanout73 _184_ VGND VGND VPWR VPWR net73 sky130_fd_sc_hd__clkbuf_4
XFILLER_9_19 VGND VGND VPWR VPWR sky130_fd_sc_hd__fill_1
X_519_ net150 net14 net62 VGND VGND VPWR VPWR _084_ sky130_fd_sc_hd__mux2_1
X_304_ reg_array\[1\]\[9\] net84 VGND VGND VPWR VPWR _153_ sky130_fd_sc_hd__and2_1
Xclkload4 clknet_3_5__leaf_clk VGND VGND VPWR VPWR clkload4/Y sky130_fd_sc_hd__clkinvlp_4
XFILLER_37_169 VPWR VGND VPWR VGND sky130_ef_sc_hd__decap_12
XFILLER_37_125 VPWR VGND VPWR VGND sky130_ef_sc_hd__decap_12
XFILLER_34_6 VPWR VGND VPWR VGND sky130_ef_sc_hd__decap_12
XFILLER_36_191 VGND VGND VPWR VPWR sky130_fd_sc_hd__decap_4
Xhold38 reg_array\[7\]\[9\] VGND VGND VPWR VPWR net138 sky130_fd_sc_hd__dlygate4sd3_1
XFILLER_28_158 VGND VGND VPWR VPWR sky130_fd_sc_hd__fill_1
Xhold27 reg_array\[6\]\[2\] VGND VGND VPWR VPWR net127 sky130_fd_sc_hd__dlygate4sd3_1
Xhold16 reg_array\[2\]\[14\] VGND VGND VPWR VPWR net116 sky130_fd_sc_hd__dlygate4sd3_1
Xhold49 reg_array\[1\]\[3\] VGND VGND VPWR VPWR net149 sky130_fd_sc_hd__dlygate4sd3_1
XPHY_EDGE_ROW_7_Left_46 VGND VGND VPWR VPWR sky130_fd_sc_hd__decap_3
XFILLER_34_139 VGND VGND VPWR VPWR sky130_fd_sc_hd__fill_1
Xoutput39 net39 VGND VGND VPWR VPWR RD1[6] sky130_fd_sc_hd__buf_2
Xoutput28 net28 VGND VGND VPWR VPWR RD1[10] sky130_fd_sc_hd__buf_2
XTAP_TAPCELL_ROW_26_189 VGND VPWR sky130_fd_sc_hd__tapvpwrvgnd_1
XFILLER_30_197 VGND VGND VPWR VPWR sky130_fd_sc_hd__fill_1
XFILLER_13_109 VGND VGND VPWR VPWR sky130_fd_sc_hd__decap_3
XFILLER_7_96 VGND VGND VPWR VPWR sky130_fd_sc_hd__fill_2
X_552_ clknet_3_6__leaf_clk _004_ VGND VGND VPWR VPWR reg_array\[4\]\[12\] sky130_fd_sc_hd__dfxtp_1
X_621_ clknet_3_6__leaf_clk _073_ VGND VGND VPWR VPWR reg_array\[5\]\[1\] sky130_fd_sc_hd__dfxtp_1
XFILLER_16_50 VGND VGND VPWR VPWR sky130_fd_sc_hd__decap_3
X_483_ net173 net12 net65 VGND VGND VPWR VPWR _050_ sky130_fd_sc_hd__mux2_1
XTAP_TAPCELL_ROW_22_170 VGND VPWR sky130_fd_sc_hd__tapvpwrvgnd_1
XFILLER_12_19 VGND VGND VPWR VPWR sky130_fd_sc_hd__fill_1
XTAP_TAPCELL_ROW_3_97 VGND VPWR sky130_fd_sc_hd__tapvpwrvgnd_1
XFILLER_37_27 VPWR VGND VPWR VGND sky130_ef_sc_hd__decap_12
XTAP_TAPCELL_ROW_11_129 VGND VPWR sky130_fd_sc_hd__tapvpwrvgnd_1
Xhold102 reg_array\[3\]\[4\] VGND VGND VPWR VPWR net202 sky130_fd_sc_hd__dlygate4sd3_1
XFILLER_5_138 VGND VGND VPWR VPWR sky130_fd_sc_hd__decap_4
XTAP_TAPCELL_ROW_5_105 VGND VPWR sky130_fd_sc_hd__tapvpwrvgnd_1
XPHY_EDGE_ROW_36_Left_75 VGND VGND VPWR VPWR sky130_fd_sc_hd__decap_3
X_397_ reg_array\[1\]\[11\] net78 VGND VGND VPWR VPWR _228_ sky130_fd_sc_hd__and2_1
X_535_ net168 net13 net60 VGND VGND VPWR VPWR _099_ sky130_fd_sc_hd__mux2_1
XPHY_EDGE_ROW_20_Left_59 VGND VGND VPWR VPWR sky130_fd_sc_hd__decap_3
X_466_ net171 net12 net68 VGND VGND VPWR VPWR _034_ sky130_fd_sc_hd__mux2_1
X_604_ clknet_3_4__leaf_clk _056_ VGND VGND VPWR VPWR reg_array\[6\]\[0\] sky130_fd_sc_hd__dfxtp_1
X_320_ reg_array\[2\]\[12\] reg_array\[3\]\[12\] net100 VGND VGND VPWR VPWR _166_
+ sky130_fd_sc_hd__mux2_1
Xfanout96 net2 VGND VGND VPWR VPWR net96 sky130_fd_sc_hd__clkbuf_4
Xfanout63 _251_ VGND VGND VPWR VPWR net63 sky130_fd_sc_hd__buf_4
Xfanout74 _184_ VGND VGND VPWR VPWR net74 sky130_fd_sc_hd__clkbuf_2
XFILLER_14_204 VGND VGND VPWR VPWR sky130_fd_sc_hd__decap_3
Xfanout85 net86 VGND VGND VPWR VPWR net85 sky130_fd_sc_hd__clkbuf_4
XTAP_TAPCELL_ROW_30_202 VGND VPWR sky130_fd_sc_hd__tapvpwrvgnd_1
X_518_ net177 net13 net61 VGND VGND VPWR VPWR _083_ sky130_fd_sc_hd__mux2_1
XFILLER_18_29 VPWR VGND VPWR VGND sky130_ef_sc_hd__decap_12
X_449_ net209 net12 net69 VGND VGND VPWR VPWR _018_ sky130_fd_sc_hd__mux2_1
Xclkload5 clknet_3_6__leaf_clk VGND VGND VPWR VPWR clkload5/X sky130_fd_sc_hd__clkbuf_4
XFILLER_37_137 VPWR VGND VPWR VGND sky130_ef_sc_hd__decap_12
X_303_ reg_array\[4\]\[9\] reg_array\[5\]\[9\] reg_array\[6\]\[9\] reg_array\[7\]\[9\]
+ net98 net96 VGND VGND VPWR VPWR _152_ sky130_fd_sc_hd__mux4_1
XPHY_EDGE_ROW_23_Left_62 VGND VGND VPWR VPWR sky130_fd_sc_hd__decap_3
XFILLER_1_65 VGND VGND VPWR VPWR sky130_fd_sc_hd__fill_1
Xhold39 reg_array\[2\]\[13\] VGND VGND VPWR VPWR net139 sky130_fd_sc_hd__dlygate4sd3_1
Xhold28 reg_array\[4\]\[9\] VGND VGND VPWR VPWR net128 sky130_fd_sc_hd__dlygate4sd3_1
Xhold17 reg_array\[5\]\[13\] VGND VGND VPWR VPWR net117 sky130_fd_sc_hd__dlygate4sd3_1
XFILLER_29_17 VGND VGND VPWR VPWR sky130_fd_sc_hd__fill_1
XFILLER_35_93 VGND VGND VPWR VPWR sky130_fd_sc_hd__fill_1
XTAP_TAPCELL_ROW_29_198 VGND VPWR sky130_fd_sc_hd__tapvpwrvgnd_1
XFILLER_3_225 VGND VGND VPWR VPWR sky130_fd_sc_hd__decap_4
XFILLER_10_85 VGND VGND VPWR VPWR sky130_fd_sc_hd__decap_6
XFILLER_25_3 VGND VGND VPWR VPWR sky130_fd_sc_hd__fill_1
Xoutput29 net29 VGND VGND VPWR VPWR RD1[11] sky130_fd_sc_hd__buf_2
XFILLER_18_181 VGND VGND VPWR VPWR sky130_fd_sc_hd__decap_4
XFILLER_15_19 VGND VGND VPWR VPWR sky130_fd_sc_hd__decap_3
XFILLER_21_84 VGND VGND VPWR VPWR sky130_fd_sc_hd__decap_3
XFILLER_16_107 VGND VGND VPWR VPWR sky130_fd_sc_hd__fill_1
X_551_ clknet_3_7__leaf_clk _003_ VGND VGND VPWR VPWR reg_array\[4\]\[11\] sky130_fd_sc_hd__dfxtp_1
XPHY_EDGE_ROW_5_Right_5 VGND VGND VPWR VPWR sky130_fd_sc_hd__decap_3
XTAP_TAPCELL_ROW_8_114 VGND VPWR sky130_fd_sc_hd__tapvpwrvgnd_1
X_620_ clknet_3_4__leaf_clk _072_ VGND VGND VPWR VPWR reg_array\[5\]\[0\] sky130_fd_sc_hd__dfxtp_1
X_482_ net122 net26 net65 VGND VGND VPWR VPWR _049_ sky130_fd_sc_hd__mux2_1
XFILLER_32_83 VGND VGND VPWR VPWR sky130_fd_sc_hd__fill_1
XTAP_TAPCELL_ROW_22_171 VGND VPWR sky130_fd_sc_hd__tapvpwrvgnd_1
XTAP_TAPCELL_ROW_14_138 VGND VPWR sky130_fd_sc_hd__tapvpwrvgnd_1
XFILLER_37_39 VPWR VGND VPWR VGND sky130_ef_sc_hd__decap_12
Xhold103 reg_array\[3\]\[13\] VGND VGND VPWR VPWR net203 sky130_fd_sc_hd__dlygate4sd3_1
X_465_ net140 net26 net67 VGND VGND VPWR VPWR _033_ sky130_fd_sc_hd__mux2_1
X_603_ clknet_3_3__leaf_clk _055_ VGND VGND VPWR VPWR reg_array\[1\]\[15\] sky130_fd_sc_hd__dfxtp_1
X_396_ reg_array\[4\]\[11\] reg_array\[5\]\[11\] reg_array\[6\]\[11\] reg_array\[7\]\[11\]
+ net92 net87 VGND VGND VPWR VPWR _227_ sky130_fd_sc_hd__mux4_1
X_534_ net204 net12 net59 VGND VGND VPWR VPWR _098_ sky130_fd_sc_hd__mux2_1
XFILLER_4_183 VPWR VGND VPWR VGND sky130_ef_sc_hd__decap_12
Xfanout97 net1 VGND VGND VPWR VPWR net97 sky130_fd_sc_hd__buf_4
Xfanout64 _251_ VGND VGND VPWR VPWR net64 sky130_fd_sc_hd__buf_2
Xfanout86 net6 VGND VGND VPWR VPWR net86 sky130_fd_sc_hd__clkbuf_4
Xfanout75 _181_ VGND VGND VPWR VPWR net75 sky130_fd_sc_hd__clkbuf_4
XFILLER_38_93 VGND VGND VPWR VPWR sky130_fd_sc_hd__fill_1
X_448_ net207 net26 net69 VGND VGND VPWR VPWR _017_ sky130_fd_sc_hd__mux2_1
XTAP_TAPCELL_ROW_30_203 VGND VPWR sky130_fd_sc_hd__tapvpwrvgnd_1
X_517_ net159 net12 net61 VGND VGND VPWR VPWR _082_ sky130_fd_sc_hd__mux2_1
X_379_ net85 _211_ _213_ net73 VGND VGND VPWR VPWR _214_ sky130_fd_sc_hd__a22o_1
XFILLER_34_18 VGND VGND VPWR VPWR sky130_fd_sc_hd__decap_8
Xclkload6 clknet_3_7__leaf_clk VGND VGND VPWR VPWR clkload6/Y sky130_fd_sc_hd__bufinv_16
XFILLER_37_149 VPWR VGND VPWR VGND sky130_ef_sc_hd__decap_12
X_302_ _149_ _151_ net82 VGND VGND VPWR VPWR net41 sky130_fd_sc_hd__o21a_1
Xhold29 reg_array\[2\]\[8\] VGND VGND VPWR VPWR net129 sky130_fd_sc_hd__dlygate4sd3_1
XFILLER_28_138 VGND VGND VPWR VPWR sky130_fd_sc_hd__fill_2
Xhold18 reg_array\[1\]\[11\] VGND VGND VPWR VPWR net118 sky130_fd_sc_hd__dlygate4sd3_1
XTAP_TAPCELL_ROW_29_199 VGND VPWR sky130_fd_sc_hd__tapvpwrvgnd_1
XFILLER_27_182 VGND VGND VPWR VPWR sky130_fd_sc_hd__fill_1
XFILLER_10_64 VGND VGND VPWR VPWR sky130_fd_sc_hd__fill_1
XFILLER_21_52 VGND VGND VPWR VPWR sky130_fd_sc_hd__decap_4
XFILLER_16_119 VGND VGND VPWR VPWR sky130_fd_sc_hd__decap_4
XFILLER_21_111 VGND VGND VPWR VPWR sky130_fd_sc_hd__fill_1
XTAP_TAPCELL_ROW_8_115 VGND VPWR sky130_fd_sc_hd__tapvpwrvgnd_1
XFILLER_35_203 VGND VGND VPWR VPWR sky130_fd_sc_hd__fill_1
X_481_ net126 net25 net66 VGND VGND VPWR VPWR _048_ sky130_fd_sc_hd__mux2_1
XTAP_TAPCELL_ROW_22_172 VGND VPWR sky130_fd_sc_hd__tapvpwrvgnd_1
XPHY_EDGE_ROW_20_Right_20 VGND VGND VPWR VPWR sky130_fd_sc_hd__decap_3
XTAP_TAPCELL_ROW_14_139 VGND VPWR sky130_fd_sc_hd__tapvpwrvgnd_1
XPHY_EDGE_ROW_11_Right_11 VGND VGND VPWR VPWR sky130_fd_sc_hd__decap_3
X_550_ clknet_3_5__leaf_clk _002_ VGND VGND VPWR VPWR reg_array\[4\]\[10\] sky130_fd_sc_hd__dfxtp_1
XFILLER_8_137 VGND VGND VPWR VPWR sky130_fd_sc_hd__decap_3
XFILLER_35_225 VGND VGND VPWR VPWR sky130_fd_sc_hd__decap_4
Xhold104 reg_array\[7\]\[10\] VGND VGND VPWR VPWR net204 sky130_fd_sc_hd__dlygate4sd3_1
XFILLER_32_228 VGND VGND VPWR VPWR sky130_fd_sc_hd__fill_1
X_533_ net138 net26 net59 VGND VGND VPWR VPWR _097_ sky130_fd_sc_hd__mux2_1
X_464_ net129 net25 net67 VGND VGND VPWR VPWR _032_ sky130_fd_sc_hd__mux2_1
X_602_ clknet_3_5__leaf_clk _054_ VGND VGND VPWR VPWR reg_array\[1\]\[14\] sky130_fd_sc_hd__dfxtp_1
XFILLER_5_129 VGND VGND VPWR VPWR sky130_fd_sc_hd__fill_1
Xclkbuf_3_2__f_clk clknet_0_clk VGND VGND VPWR VPWR clknet_3_2__leaf_clk sky130_fd_sc_hd__clkbuf_16
X_395_ _224_ _226_ net75 VGND VGND VPWR VPWR net44 sky130_fd_sc_hd__o21a_1
XFILLER_4_195 VGND VGND VPWR VPWR sky130_fd_sc_hd__fill_1
Xfanout98 net1 VGND VGND VPWR VPWR net98 sky130_fd_sc_hd__buf_2
Xfanout87 net88 VGND VGND VPWR VPWR net87 sky130_fd_sc_hd__clkbuf_4
Xfanout76 _181_ VGND VGND VPWR VPWR net76 sky130_fd_sc_hd__buf_2
Xfanout65 _250_ VGND VGND VPWR VPWR net65 sky130_fd_sc_hd__buf_4
XFILLER_38_83 VGND VGND VPWR VPWR sky130_fd_sc_hd__fill_1
X_447_ net197 net25 net70 VGND VGND VPWR VPWR _016_ sky130_fd_sc_hd__mux2_1
X_516_ net106 net26 net62 VGND VGND VPWR VPWR _081_ sky130_fd_sc_hd__mux2_1
XTAP_TAPCELL_ROW_30_204 VGND VPWR sky130_fd_sc_hd__tapvpwrvgnd_1
XFILLER_1_110 VGND VGND VPWR VPWR sky130_fd_sc_hd__fill_2
XTAP_TAPCELL_ROW_0_78 VGND VPWR sky130_fd_sc_hd__tapvpwrvgnd_1
X_378_ reg_array\[2\]\[7\] reg_array\[3\]\[7\] net89 VGND VGND VPWR VPWR _213_ sky130_fd_sc_hd__mux2_1
XFILLER_37_106 VGND VGND VPWR VPWR sky130_fd_sc_hd__decap_6
X_301_ net94 _148_ _150_ net79 VGND VGND VPWR VPWR _151_ sky130_fd_sc_hd__a22o_1
XFILLER_28_128 VGND VGND VPWR VPWR sky130_fd_sc_hd__fill_2
Xhold19 reg_array\[5\]\[4\] VGND VGND VPWR VPWR net119 sky130_fd_sc_hd__dlygate4sd3_1
XFILLER_25_109 VGND VGND VPWR VPWR sky130_fd_sc_hd__decap_3
XFILLER_18_194 VGND VGND VPWR VPWR sky130_fd_sc_hd__fill_2
XFILLER_21_42 VGND VGND VPWR VPWR sky130_fd_sc_hd__fill_1
XFILLER_15_164 VGND VGND VPWR VPWR sky130_fd_sc_hd__decap_4
XFILLER_38_223 VGND VGND VPWR VPWR sky130_fd_sc_hd__fill_1
XFILLER_30_3 VGND VGND VPWR VPWR sky130_fd_sc_hd__decap_4
XTAP_TAPCELL_ROW_8_116 VGND VPWR sky130_fd_sc_hd__tapvpwrvgnd_1
XFILLER_32_85 VGND VGND VPWR VPWR sky130_fd_sc_hd__fill_1
XTAP_TAPCELL_ROW_22_173 VGND VPWR sky130_fd_sc_hd__tapvpwrvgnd_1
X_480_ net114 net24 net65 VGND VGND VPWR VPWR _047_ sky130_fd_sc_hd__mux2_1
Xhold105 reg_array\[6\]\[9\] VGND VGND VPWR VPWR net205 sky130_fd_sc_hd__dlygate4sd3_1
X_601_ clknet_3_3__leaf_clk _053_ VGND VGND VPWR VPWR reg_array\[1\]\[13\] sky130_fd_sc_hd__dfxtp_1
X_532_ net125 net25 net60 VGND VGND VPWR VPWR _096_ sky130_fd_sc_hd__mux2_1
X_394_ net86 _223_ _225_ net74 VGND VGND VPWR VPWR _226_ sky130_fd_sc_hd__a22o_1
X_463_ net120 net24 net67 VGND VGND VPWR VPWR _031_ sky130_fd_sc_hd__mux2_1
X_515_ net104 net25 net62 VGND VGND VPWR VPWR _080_ sky130_fd_sc_hd__mux2_1
Xfanout88 net5 VGND VGND VPWR VPWR net88 sky130_fd_sc_hd__clkbuf_4
XTAP_TAPCELL_ROW_30_205 VGND VPWR sky130_fd_sc_hd__tapvpwrvgnd_1
Xfanout66 _250_ VGND VGND VPWR VPWR net66 sky130_fd_sc_hd__buf_2
Xfanout99 net1 VGND VGND VPWR VPWR net99 sky130_fd_sc_hd__clkbuf_4
XFILLER_13_76 VGND VGND VPWR VPWR sky130_fd_sc_hd__decap_3
XFILLER_13_43 VGND VGND VPWR VPWR sky130_fd_sc_hd__decap_4
Xfanout77 _180_ VGND VGND VPWR VPWR net77 sky130_fd_sc_hd__buf_2
XFILLER_1_133 VGND VGND VPWR VPWR sky130_fd_sc_hd__fill_2
X_377_ reg_array\[1\]\[7\] net77 VGND VGND VPWR VPWR _212_ sky130_fd_sc_hd__and2_1
XTAP_TAPCELL_ROW_0_79 VGND VPWR sky130_fd_sc_hd__tapvpwrvgnd_1
X_446_ net206 net24 net69 VGND VGND VPWR VPWR _015_ sky130_fd_sc_hd__mux2_1
XFILLER_8_3 VGND VGND VPWR VPWR sky130_fd_sc_hd__decap_8
X_300_ reg_array\[2\]\[8\] reg_array\[3\]\[8\] net100 VGND VGND VPWR VPWR _150_ sky130_fd_sc_hd__mux2_1
X_429_ net154 net24 net71 VGND VGND VPWR VPWR _111_ sky130_fd_sc_hd__mux2_1
XFILLER_36_195 VGND VGND VPWR VPWR sky130_fd_sc_hd__fill_1
Xinput1 A1[0] VGND VGND VPWR VPWR net1 sky130_fd_sc_hd__clkbuf_2
XFILLER_3_206 VPWR VGND VPWR VGND sky130_ef_sc_hd__decap_12
XPHY_EDGE_ROW_27_Left_66 VGND VGND VPWR VPWR sky130_fd_sc_hd__decap_3
XFILLER_33_187 VGND VGND VPWR VPWR sky130_fd_sc_hd__decap_8
XFILLER_33_121 VGND VGND VPWR VPWR sky130_fd_sc_hd__decap_3
XFILLER_0_209 VPWR VGND VPWR VGND sky130_ef_sc_hd__decap_12
XTAP_TAPCELL_ROW_25_182 VGND VPWR sky130_fd_sc_hd__tapvpwrvgnd_1
XFILLER_21_65 VGND VGND VPWR VPWR sky130_fd_sc_hd__decap_4
XFILLER_15_143 VGND VGND VPWR VPWR sky130_fd_sc_hd__decap_4
XFILLER_29_202 VGND VGND VPWR VPWR sky130_fd_sc_hd__decap_3
XFILLER_12_157 VGND VGND VPWR VPWR sky130_fd_sc_hd__decap_3
XTAP_TAPCELL_ROW_8_117 VGND VPWR sky130_fd_sc_hd__tapvpwrvgnd_1
Xhold106 reg_array\[3\]\[7\] VGND VGND VPWR VPWR net206 sky130_fd_sc_hd__dlygate4sd3_1
XFILLER_7_150 VPWR VGND VPWR VGND sky130_ef_sc_hd__decap_12
XPHY_EDGE_ROW_9_Right_9 VGND VGND VPWR VPWR sky130_fd_sc_hd__decap_3
XPHY_EDGE_ROW_14_Left_53 VGND VGND VPWR VPWR sky130_fd_sc_hd__decap_3
X_600_ clknet_3_6__leaf_clk _052_ VGND VGND VPWR VPWR reg_array\[1\]\[12\] sky130_fd_sc_hd__dfxtp_1
XFILLER_27_64 VGND VGND VPWR VPWR sky130_fd_sc_hd__fill_1
X_462_ net211 net23 net67 VGND VGND VPWR VPWR _030_ sky130_fd_sc_hd__mux2_1
X_393_ reg_array\[2\]\[10\] reg_array\[3\]\[10\] net91 VGND VGND VPWR VPWR _225_ sky130_fd_sc_hd__mux2_1
XFILLER_4_197 VGND VGND VPWR VPWR sky130_fd_sc_hd__decap_8
X_531_ net158 net24 net59 VGND VGND VPWR VPWR _095_ sky130_fd_sc_hd__mux2_1
XTAP_TAPCELL_ROW_10_122 VGND VPWR sky130_fd_sc_hd__tapvpwrvgnd_1
XTAP_TAPCELL_ROW_33_214 VGND VPWR sky130_fd_sc_hd__tapvpwrvgnd_1
XFILLER_38_85 VGND VGND VPWR VPWR sky130_fd_sc_hd__decap_8
XFILLER_38_41 VPWR VGND VPWR VGND sky130_ef_sc_hd__decap_12
Xfanout89 net4 VGND VGND VPWR VPWR net89 sky130_fd_sc_hd__clkbuf_4
Xfanout78 _180_ VGND VGND VPWR VPWR net78 sky130_fd_sc_hd__clkbuf_2
Xfanout67 _249_ VGND VGND VPWR VPWR net67 sky130_fd_sc_hd__buf_4
XFILLER_13_66 VGND VGND VPWR VPWR sky130_fd_sc_hd__fill_2
X_514_ net132 net24 net61 VGND VGND VPWR VPWR _079_ sky130_fd_sc_hd__mux2_1
XFILLER_1_167 VGND VGND VPWR VPWR sky130_fd_sc_hd__fill_1
X_445_ net212 net23 net69 VGND VGND VPWR VPWR _014_ sky130_fd_sc_hd__mux2_1
X_376_ reg_array\[4\]\[7\] reg_array\[5\]\[7\] reg_array\[6\]\[7\] reg_array\[7\]\[7\]
+ net89 net88 VGND VGND VPWR VPWR _211_ sky130_fd_sc_hd__mux4_1
X_428_ net188 net23 net71 VGND VGND VPWR VPWR _110_ sky130_fd_sc_hd__mux2_1
X_359_ net85 _195_ _197_ net73 VGND VGND VPWR VPWR _198_ sky130_fd_sc_hd__a22o_1
Xinput2 A1[1] VGND VGND VPWR VPWR net2 sky130_fd_sc_hd__buf_1
XFILLER_3_218 VGND VGND VPWR VPWR sky130_fd_sc_hd__decap_6
XFILLER_19_32 VPWR VGND VPWR VGND sky130_ef_sc_hd__decap_12
XPHY_EDGE_ROW_2_Left_41 VGND VGND VPWR VPWR sky130_fd_sc_hd__decap_3
XFILLER_33_133 VGND VGND VPWR VPWR sky130_fd_sc_hd__fill_2
XFILLER_15_100 VGND VGND VPWR VPWR sky130_fd_sc_hd__decap_4
XFILLER_38_225 VGND VGND VPWR VPWR sky130_fd_sc_hd__decap_4
XFILLER_38_203 VPWR VGND VPWR VGND sky130_ef_sc_hd__decap_12
XTAP_TAPCELL_ROW_25_183 VGND VPWR sky130_fd_sc_hd__tapvpwrvgnd_1
XFILLER_15_177 VGND VGND VPWR VPWR sky130_fd_sc_hd__decap_8
XFILLER_15_122 VPWR VGND VPWR VGND sky130_ef_sc_hd__decap_12
XFILLER_12_114 VPWR VGND VPWR VGND sky130_ef_sc_hd__decap_12
Xhold107 reg_array\[3\]\[9\] VGND VGND VPWR VPWR net207 sky130_fd_sc_hd__dlygate4sd3_1
XFILLER_7_162 VGND VGND VPWR VPWR sky130_fd_sc_hd__decap_6
XFILLER_7_173 VGND VGND VPWR VPWR sky130_fd_sc_hd__fill_1
X_530_ net111 net23 net59 VGND VGND VPWR VPWR _094_ sky130_fd_sc_hd__mux2_1
X_461_ net152 net22 net67 VGND VGND VPWR VPWR _029_ sky130_fd_sc_hd__mux2_1
X_392_ reg_array\[1\]\[10\] net77 VGND VGND VPWR VPWR _224_ sky130_fd_sc_hd__and2_1
XTAP_TAPCELL_ROW_10_123 VGND VPWR sky130_fd_sc_hd__tapvpwrvgnd_1
XTAP_TAPCELL_ROW_33_215 VGND VPWR sky130_fd_sc_hd__tapvpwrvgnd_1
XPHY_EDGE_ROW_31_Left_70 VGND VGND VPWR VPWR sky130_fd_sc_hd__decap_3
XFILLER_38_53 VGND VGND VPWR VPWR sky130_fd_sc_hd__decap_3
Xfanout68 _249_ VGND VGND VPWR VPWR net68 sky130_fd_sc_hd__buf_2
XFILLER_1_113 VPWR VGND VPWR VGND sky130_ef_sc_hd__decap_12
XFILLER_1_102 VGND VGND VPWR VPWR sky130_fd_sc_hd__decap_8
Xfanout79 _121_ VGND VGND VPWR VPWR net79 sky130_fd_sc_hd__clkbuf_4
X_375_ _208_ _210_ net75 VGND VGND VPWR VPWR net55 sky130_fd_sc_hd__o21a_1
X_513_ net135 net23 net61 VGND VGND VPWR VPWR _078_ sky130_fd_sc_hd__mux2_1
X_444_ net187 net22 net69 VGND VGND VPWR VPWR _013_ sky130_fd_sc_hd__mux2_1
X_358_ reg_array\[2\]\[3\] reg_array\[3\]\[3\] net89 VGND VGND VPWR VPWR _197_ sky130_fd_sc_hd__mux2_1
XFILLER_1_15 VPWR VGND VPWR VGND sky130_ef_sc_hd__decap_12
X_427_ net181 net22 net71 VGND VGND VPWR VPWR _109_ sky130_fd_sc_hd__mux2_1
XFILLER_36_197 VPWR VGND VPWR VGND sky130_ef_sc_hd__decap_12
XFILLER_36_131 VGND VGND VPWR VPWR sky130_fd_sc_hd__decap_8
X_289_ reg_array\[1\]\[6\] net83 VGND VGND VPWR VPWR _141_ sky130_fd_sc_hd__and2_1
XPHY_EDGE_ROW_27_Right_27 VGND VGND VPWR VPWR sky130_fd_sc_hd__decap_3
XPHY_EDGE_ROW_18_Right_18 VGND VGND VPWR VPWR sky130_fd_sc_hd__decap_3
Xinput3 A1[2] VGND VGND VPWR VPWR net3 sky130_fd_sc_hd__buf_1
XPHY_EDGE_ROW_36_Right_36 VGND VGND VPWR VPWR sky130_fd_sc_hd__decap_3
XFILLER_35_43 VPWR VGND VPWR VGND sky130_ef_sc_hd__decap_12
XFILLER_19_99 VGND VGND VPWR VPWR sky130_fd_sc_hd__decap_4
XFILLER_19_44 VGND VGND VPWR VPWR sky130_fd_sc_hd__fill_2
XFILLER_18_7 VGND VGND VPWR VPWR sky130_fd_sc_hd__fill_2
XFILLER_24_167 VGND VGND VPWR VPWR sky130_fd_sc_hd__decap_4
XFILLER_21_34 VGND VGND VPWR VPWR sky130_fd_sc_hd__decap_8
XFILLER_2_80 VGND VGND VPWR VPWR sky130_fd_sc_hd__decap_4
XFILLER_38_215 VGND VGND VPWR VPWR sky130_fd_sc_hd__decap_8
XFILLER_30_148 VGND VGND VPWR VPWR sky130_fd_sc_hd__decap_4
XTAP_TAPCELL_ROW_25_184 VGND VPWR sky130_fd_sc_hd__tapvpwrvgnd_1
XFILLER_12_126 VGND VGND VPWR VPWR sky130_fd_sc_hd__decap_4
XPHY_EDGE_ROW_0_Right_0 VGND VGND VPWR VPWR sky130_fd_sc_hd__decap_3
Xhold108 reg_array\[3\]\[1\] VGND VGND VPWR VPWR net208 sky130_fd_sc_hd__dlygate4sd3_1
XFILLER_27_55 VGND VGND VPWR VPWR sky130_fd_sc_hd__fill_1
X_391_ reg_array\[4\]\[10\] reg_array\[5\]\[10\] reg_array\[6\]\[10\] reg_array\[7\]\[10\]
+ net91 net87 VGND VGND VPWR VPWR _223_ sky130_fd_sc_hd__mux4_1
XTAP_TAPCELL_ROW_10_124 VGND VPWR sky130_fd_sc_hd__tapvpwrvgnd_1
XTAP_TAPCELL_ROW_4_100 VGND VPWR sky130_fd_sc_hd__tapvpwrvgnd_1
X_460_ net144 net21 net68 VGND VGND VPWR VPWR _028_ sky130_fd_sc_hd__mux2_1
XTAP_TAPCELL_ROW_33_216 VGND VPWR sky130_fd_sc_hd__tapvpwrvgnd_1
X_589_ clknet_3_7__leaf_clk _041_ VGND VGND VPWR VPWR reg_array\[1\]\[1\] sky130_fd_sc_hd__dfxtp_1
XFILLER_4_15 VPWR VGND VPWR VGND sky130_ef_sc_hd__decap_12
Xfanout69 _248_ VGND VGND VPWR VPWR net69 sky130_fd_sc_hd__buf_4
XFILLER_1_125 VGND VGND VPWR VPWR sky130_fd_sc_hd__decap_8
X_374_ net85 _207_ _209_ net73 VGND VGND VPWR VPWR _210_ sky130_fd_sc_hd__a22o_1
XFILLER_1_169 VPWR VGND VPWR VGND sky130_ef_sc_hd__decap_12
X_443_ net202 net21 net69 VGND VGND VPWR VPWR _012_ sky130_fd_sc_hd__mux2_1
X_512_ net156 net22 net61 VGND VGND VPWR VPWR _077_ sky130_fd_sc_hd__mux2_1
XFILLER_1_27 VPWR VGND VPWR VGND sky130_ef_sc_hd__decap_12
XFILLER_6_206 VGND VGND VPWR VPWR sky130_fd_sc_hd__fill_1
XFILLER_6_217 VGND VGND VPWR VPWR sky130_fd_sc_hd__fill_1
XFILLER_36_165 VGND VGND VPWR VPWR sky130_fd_sc_hd__decap_6
Xinput4 A2[0] VGND VGND VPWR VPWR net4 sky130_fd_sc_hd__dlymetal6s2s_1
X_288_ reg_array\[4\]\[6\] reg_array\[5\]\[6\] reg_array\[6\]\[6\] reg_array\[7\]\[6\]
+ net97 net96 VGND VGND VPWR VPWR _140_ sky130_fd_sc_hd__mux4_1
X_357_ reg_array\[1\]\[3\] net77 VGND VGND VPWR VPWR _196_ sky130_fd_sc_hd__and2_1
X_426_ net194 net21 net71 VGND VGND VPWR VPWR _108_ sky130_fd_sc_hd__mux2_1
XFILLER_35_77 VPWR VGND VPWR VGND sky130_ef_sc_hd__decap_12
XFILLER_35_55 VGND VGND VPWR VPWR sky130_fd_sc_hd__fill_1
XFILLER_33_113 VGND VGND VPWR VPWR sky130_fd_sc_hd__decap_8
X_409_ net85 _235_ _237_ net73 VGND VGND VPWR VPWR _238_ sky130_fd_sc_hd__a22o_1
XTAP_TAPCELL_ROW_19_160 VGND VPWR sky130_fd_sc_hd__tapvpwrvgnd_1
XFILLER_2_70 VGND VGND VPWR VPWR sky130_fd_sc_hd__fill_1
XFILLER_30_116 VPWR VGND VPWR VGND sky130_ef_sc_hd__decap_12
XFILLER_30_7 VGND VGND VPWR VPWR sky130_fd_sc_hd__fill_1
XTAP_TAPCELL_ROW_25_185 VGND VPWR sky130_fd_sc_hd__tapvpwrvgnd_1
XFILLER_11_90 VGND VGND VPWR VPWR sky130_fd_sc_hd__decap_3
Xhold109 reg_array\[3\]\[10\] VGND VGND VPWR VPWR net209 sky130_fd_sc_hd__dlygate4sd3_1
X_390_ _220_ _222_ net76 VGND VGND VPWR VPWR net58 sky130_fd_sc_hd__o21a_1
XTAP_TAPCELL_ROW_4_101 VGND VPWR sky130_fd_sc_hd__tapvpwrvgnd_1
XTAP_TAPCELL_ROW_33_217 VGND VPWR sky130_fd_sc_hd__tapvpwrvgnd_1
XTAP_TAPCELL_ROW_10_125 VGND VPWR sky130_fd_sc_hd__tapvpwrvgnd_1
XFILLER_4_27 VGND VGND VPWR VPWR sky130_fd_sc_hd__fill_1
XFILLER_4_123 VGND VGND VPWR VPWR sky130_fd_sc_hd__fill_1
X_588_ clknet_3_5__leaf_clk _040_ VGND VGND VPWR VPWR reg_array\[1\]\[0\] sky130_fd_sc_hd__dfxtp_1
XPHY_EDGE_ROW_18_Left_57 VGND VGND VPWR VPWR sky130_fd_sc_hd__decap_3
Xfanout59 _253_ VGND VGND VPWR VPWR net59 sky130_fd_sc_hd__buf_4
XFILLER_38_77 VGND VGND VPWR VPWR sky130_fd_sc_hd__decap_6
X_373_ reg_array\[2\]\[6\] reg_array\[3\]\[6\] net90 VGND VGND VPWR VPWR _209_ sky130_fd_sc_hd__mux2_1
X_442_ net201 net20 net70 VGND VGND VPWR VPWR _011_ sky130_fd_sc_hd__mux2_1
X_511_ net119 net21 net61 VGND VGND VPWR VPWR _076_ sky130_fd_sc_hd__mux2_1
XFILLER_9_215 VGND VGND VPWR VPWR sky130_fd_sc_hd__fill_1
Xinput5 A2[1] VGND VGND VPWR VPWR net5 sky130_fd_sc_hd__clkbuf_1
X_356_ reg_array\[4\]\[3\] reg_array\[5\]\[3\] reg_array\[6\]\[3\] reg_array\[7\]\[3\]
+ net89 net88 VGND VGND VPWR VPWR _195_ sky130_fd_sc_hd__mux4_1
X_425_ net191 net20 net71 VGND VGND VPWR VPWR _107_ sky130_fd_sc_hd__mux2_1
X_287_ _137_ _139_ net81 VGND VGND VPWR VPWR net38 sky130_fd_sc_hd__o21a_1
XFILLER_1_39 VGND VGND VPWR VPWR sky130_fd_sc_hd__fill_1
XFILLER_10_15 VGND VGND VPWR VPWR sky130_fd_sc_hd__decap_4
XFILLER_35_89 VGND VGND VPWR VPWR sky130_fd_sc_hd__decap_4
XFILLER_33_169 VGND VGND VPWR VPWR sky130_fd_sc_hd__fill_2
X_408_ reg_array\[2\]\[13\] reg_array\[3\]\[13\] net90 VGND VGND VPWR VPWR _237_ sky130_fd_sc_hd__mux2_1
XTAP_TAPCELL_ROW_28_194 VGND VPWR sky130_fd_sc_hd__tapvpwrvgnd_1
XFILLER_18_133 VGND VGND VPWR VPWR sky130_fd_sc_hd__decap_6
XFILLER_2_221 VGND VGND VPWR VPWR sky130_fd_sc_hd__decap_8
XTAP_TAPCELL_ROW_19_161 VGND VPWR sky130_fd_sc_hd__tapvpwrvgnd_1
X_339_ net85 net89 net88 VGND VGND VPWR VPWR _181_ sky130_fd_sc_hd__or3_1
XFILLER_30_128 VGND VGND VPWR VPWR sky130_fd_sc_hd__decap_6
XFILLER_21_69 VGND VGND VPWR VPWR sky130_fd_sc_hd__fill_1
XPHY_EDGE_ROW_6_Left_45 VGND VGND VPWR VPWR sky130_fd_sc_hd__decap_3
XFILLER_14_180 VGND VGND VPWR VPWR sky130_fd_sc_hd__fill_1
XFILLER_32_13 VGND VGND VPWR VPWR sky130_fd_sc_hd__decap_3
XFILLER_20_150 VGND VGND VPWR VPWR sky130_fd_sc_hd__decap_3
XFILLER_12_139 VGND VGND VPWR VPWR sky130_fd_sc_hd__fill_1
XTAP_TAPCELL_ROW_7_110 VGND VPWR sky130_fd_sc_hd__tapvpwrvgnd_1
XFILLER_22_90 VGND VGND VPWR VPWR sky130_fd_sc_hd__fill_1
XTAP_TAPCELL_ROW_13_134 VGND VPWR sky130_fd_sc_hd__tapvpwrvgnd_1
XTAP_TAPCELL_ROW_36_226 VGND VPWR sky130_fd_sc_hd__tapvpwrvgnd_1
XFILLER_8_81 VGND VGND VPWR VPWR sky130_fd_sc_hd__decap_3
X_587_ clknet_3_3__leaf_clk _039_ VGND VGND VPWR VPWR reg_array\[2\]\[15\] sky130_fd_sc_hd__dfxtp_1
XFILLER_31_223 VGND VGND VPWR VPWR sky130_fd_sc_hd__fill_1
XFILLER_13_15 VGND VGND VPWR VPWR sky130_fd_sc_hd__decap_4
XPHY_EDGE_ROW_35_Left_74 VGND VGND VPWR VPWR sky130_fd_sc_hd__decap_3
X_372_ reg_array\[1\]\[6\] net77 VGND VGND VPWR VPWR _208_ sky130_fd_sc_hd__and2_1
X_510_ net183 net20 net61 VGND VGND VPWR VPWR _075_ sky130_fd_sc_hd__mux2_1
XFILLER_13_223 VGND VGND VPWR VPWR sky130_fd_sc_hd__fill_1
X_441_ net192 net19 net69 VGND VGND VPWR VPWR _010_ sky130_fd_sc_hd__mux2_1
X_639_ clknet_3_0__leaf_clk _091_ VGND VGND VPWR VPWR reg_array\[7\]\[3\] sky130_fd_sc_hd__dfxtp_1
X_424_ net170 net19 net71 VGND VGND VPWR VPWR _106_ sky130_fd_sc_hd__mux2_1
X_355_ _192_ _194_ net75 VGND VGND VPWR VPWR net51 sky130_fd_sc_hd__o21a_1
X_286_ net93 _136_ _138_ net79 VGND VGND VPWR VPWR _139_ sky130_fd_sc_hd__a22o_1
Xinput6 A2[2] VGND VGND VPWR VPWR net6 sky130_fd_sc_hd__clkbuf_1
XFILLER_10_38 VGND VGND VPWR VPWR sky130_fd_sc_hd__decap_6
XFILLER_35_35 VGND VGND VPWR VPWR sky130_fd_sc_hd__decap_4
XFILLER_27_178 VGND VGND VPWR VPWR sky130_fd_sc_hd__decap_4
Xclkbuf_3_3__f_clk clknet_0_clk VGND VGND VPWR VPWR clknet_3_3__leaf_clk sky130_fd_sc_hd__clkbuf_16
XPHY_EDGE_ROW_23_Right_23 VGND VGND VPWR VPWR sky130_fd_sc_hd__decap_3
XPHY_EDGE_ROW_14_Right_14 VGND VGND VPWR VPWR sky130_fd_sc_hd__decap_3
X_407_ reg_array\[1\]\[13\] net78 VGND VGND VPWR VPWR _236_ sky130_fd_sc_hd__and2_1
XFILLER_33_148 VPWR VGND VPWR VGND sky130_ef_sc_hd__decap_12
XPHY_EDGE_ROW_32_Right_32 VGND VGND VPWR VPWR sky130_fd_sc_hd__decap_3
XTAP_TAPCELL_ROW_28_195 VGND VPWR sky130_fd_sc_hd__tapvpwrvgnd_1
XPHY_EDGE_ROW_22_Left_61 VGND VGND VPWR VPWR sky130_fd_sc_hd__decap_3
X_338_ net85 net87 VGND VGND VPWR VPWR _180_ sky130_fd_sc_hd__nor2_1
XFILLER_2_61 VGND VGND VPWR VPWR sky130_fd_sc_hd__decap_4
X_269_ reg_array\[1\]\[2\] net83 VGND VGND VPWR VPWR _125_ sky130_fd_sc_hd__and2_1
XFILLER_21_129 VGND VGND VPWR VPWR sky130_fd_sc_hd__fill_1
Xinput20 WD3[3] VGND VGND VPWR VPWR net20 sky130_fd_sc_hd__dlymetal6s2s_1
XFILLER_32_25 VGND VGND VPWR VPWR sky130_fd_sc_hd__decap_3
XTAP_TAPCELL_ROW_13_135 VGND VPWR sky130_fd_sc_hd__tapvpwrvgnd_1
XFILLER_7_111 VGND VGND VPWR VPWR sky130_fd_sc_hd__fill_1
XTAP_TAPCELL_ROW_7_111 VGND VPWR sky130_fd_sc_hd__tapvpwrvgnd_1
XTAP_TAPCELL_ROW_36_227 VGND VPWR sky130_fd_sc_hd__tapvpwrvgnd_1
XPHY_EDGE_ROW_4_Right_4 VGND VGND VPWR VPWR sky130_fd_sc_hd__decap_3
XFILLER_4_158 VGND VGND VPWR VPWR sky130_fd_sc_hd__fill_1
X_586_ clknet_3_5__leaf_clk _038_ VGND VGND VPWR VPWR reg_array\[2\]\[14\] sky130_fd_sc_hd__dfxtp_1
XFILLER_38_57 VGND VGND VPWR VPWR sky130_fd_sc_hd__fill_2
X_371_ reg_array\[4\]\[6\] reg_array\[5\]\[6\] reg_array\[6\]\[6\] reg_array\[7\]\[6\]
+ net89 net88 VGND VGND VPWR VPWR _207_ sky130_fd_sc_hd__mux4_1
X_440_ net208 net18 net70 VGND VGND VPWR VPWR _009_ sky130_fd_sc_hd__mux2_1
X_569_ clknet_3_3__leaf_clk _021_ VGND VGND VPWR VPWR reg_array\[3\]\[13\] sky130_fd_sc_hd__dfxtp_1
X_638_ clknet_3_1__leaf_clk _090_ VGND VGND VPWR VPWR reg_array\[7\]\[2\] sky130_fd_sc_hd__dfxtp_1
XFILLER_0_161 VGND VGND VPWR VPWR sky130_fd_sc_hd__decap_6
X_423_ net210 net18 net72 VGND VGND VPWR VPWR _105_ sky130_fd_sc_hd__mux2_1
X_354_ net85 _191_ _193_ net73 VGND VGND VPWR VPWR _194_ sky130_fd_sc_hd__a22o_1
X_285_ reg_array\[2\]\[5\] reg_array\[3\]\[5\] net97 VGND VGND VPWR VPWR _138_ sky130_fd_sc_hd__mux2_1
XFILLER_5_220 VGND VGND VPWR VPWR sky130_fd_sc_hd__decap_4
XFILLER_36_179 VPWR VGND VPWR VGND sky130_ef_sc_hd__decap_12
XFILLER_30_91 VGND VGND VPWR VPWR sky130_fd_sc_hd__fill_1
Xinput7 A3[0] VGND VGND VPWR VPWR net7 sky130_fd_sc_hd__buf_1
XFILLER_27_113 VGND VGND VPWR VPWR sky130_fd_sc_hd__decap_4
XFILLER_4_3 VPWR VGND VPWR VGND sky130_ef_sc_hd__decap_12
XFILLER_37_3 VPWR VGND VPWR VGND sky130_ef_sc_hd__decap_12
XTAP_TAPCELL_ROW_28_196 VGND VPWR sky130_fd_sc_hd__tapvpwrvgnd_1
X_406_ reg_array\[4\]\[13\] reg_array\[5\]\[13\] reg_array\[6\]\[13\] reg_array\[7\]\[13\]
+ net90 net88 VGND VGND VPWR VPWR _235_ sky130_fd_sc_hd__mux4_1
X_337_ _177_ _179_ net82 VGND VGND VPWR VPWR net33 sky130_fd_sc_hd__o21a_1
X_268_ reg_array\[4\]\[2\] reg_array\[5\]\[2\] reg_array\[6\]\[2\] reg_array\[7\]\[2\]
+ net97 net96 VGND VGND VPWR VPWR _124_ sky130_fd_sc_hd__mux4_1
XFILLER_32_193 VGND VGND VPWR VPWR sky130_fd_sc_hd__decap_3
XFILLER_24_149 VGND VGND VPWR VPWR sky130_fd_sc_hd__fill_2
Xinput10 RegWrite VGND VGND VPWR VPWR net10 sky130_fd_sc_hd__clkbuf_2
Xinput21 WD3[4] VGND VGND VPWR VPWR net21 sky130_fd_sc_hd__dlymetal6s2s_1
XFILLER_20_174 VGND VGND VPWR VPWR sky130_fd_sc_hd__decap_6
XTAP_TAPCELL_ROW_13_136 VGND VPWR sky130_fd_sc_hd__tapvpwrvgnd_1
XTAP_TAPCELL_ROW_7_112 VGND VPWR sky130_fd_sc_hd__tapvpwrvgnd_1
XTAP_TAPCELL_ROW_36_228 VGND VPWR sky130_fd_sc_hd__tapvpwrvgnd_1
XFILLER_21_6 VPWR VGND VPWR VGND sky130_ef_sc_hd__decap_12
XFILLER_33_91 VGND VGND VPWR VPWR sky130_fd_sc_hd__fill_1
X_585_ clknet_3_3__leaf_clk _037_ VGND VGND VPWR VPWR reg_array\[2\]\[13\] sky130_fd_sc_hd__dfxtp_1
XFILLER_3_181 VGND VGND VPWR VPWR sky130_fd_sc_hd__fill_1
X_637_ clknet_3_6__leaf_clk _089_ VGND VGND VPWR VPWR reg_array\[7\]\[1\] sky130_fd_sc_hd__dfxtp_1
XFILLER_0_195 VGND VGND VPWR VPWR sky130_fd_sc_hd__fill_1
X_370_ _204_ _206_ net75 VGND VGND VPWR VPWR net54 sky130_fd_sc_hd__o21a_1
X_499_ net205 net26 net63 VGND VGND VPWR VPWR _065_ sky130_fd_sc_hd__mux2_1
X_568_ clknet_3_6__leaf_clk _020_ VGND VGND VPWR VPWR reg_array\[3\]\[12\] sky130_fd_sc_hd__dfxtp_1
XFILLER_5_40 VGND VGND VPWR VPWR sky130_fd_sc_hd__decap_6
XFILLER_5_95 VGND VGND VPWR VPWR sky130_fd_sc_hd__decap_4
X_284_ reg_array\[1\]\[5\] net83 VGND VGND VPWR VPWR _137_ sky130_fd_sc_hd__and2_1
X_422_ net176 net11 net71 VGND VGND VPWR VPWR _104_ sky130_fd_sc_hd__mux2_1
X_353_ reg_array\[2\]\[2\] reg_array\[3\]\[2\] net89 VGND VGND VPWR VPWR _193_ sky130_fd_sc_hd__mux2_1
Xinput8 A3[1] VGND VGND VPWR VPWR net8 sky130_fd_sc_hd__buf_1
X_405_ _232_ _234_ net76 VGND VGND VPWR VPWR net46 sky130_fd_sc_hd__o21a_1
X_267_ _120_ _123_ net81 VGND VGND VPWR VPWR net34 sky130_fd_sc_hd__o21a_1
XTAP_TAPCELL_ROW_28_197 VGND VPWR sky130_fd_sc_hd__tapvpwrvgnd_1
XFILLER_25_92 VGND VGND VPWR VPWR sky130_fd_sc_hd__fill_1
X_336_ net3 _176_ _178_ net80 VGND VGND VPWR VPWR _179_ sky130_fd_sc_hd__a22o_1
XFILLER_2_41 VPWR VGND VPWR VGND sky130_ef_sc_hd__decap_12
XFILLER_23_194 VGND VGND VPWR VPWR sky130_fd_sc_hd__fill_1
XFILLER_7_19 VGND VGND VPWR VPWR sky130_fd_sc_hd__fill_2
X_319_ reg_array\[1\]\[12\] net84 VGND VGND VPWR VPWR _165_ sky130_fd_sc_hd__and2_1
XFILLER_14_172 VGND VGND VPWR VPWR sky130_fd_sc_hd__decap_8
XFILLER_14_161 VGND VGND VPWR VPWR sky130_fd_sc_hd__decap_3
Xinput11 WD3[0] VGND VGND VPWR VPWR net11 sky130_fd_sc_hd__clkbuf_2
Xinput22 WD3[5] VGND VGND VPWR VPWR net22 sky130_fd_sc_hd__clkbuf_2
XTAP_TAPCELL_ROW_7_113 VGND VPWR sky130_fd_sc_hd__tapvpwrvgnd_1
XTAP_TAPCELL_ROW_36_229 VGND VPWR sky130_fd_sc_hd__tapvpwrvgnd_1
XTAP_TAPCELL_ROW_13_137 VGND VPWR sky130_fd_sc_hd__tapvpwrvgnd_1
XFILLER_11_120 VGND VGND VPWR VPWR sky130_fd_sc_hd__decap_6
XFILLER_7_113 VPWR VGND VPWR VGND sky130_ef_sc_hd__decap_12
XFILLER_27_38 VGND VGND VPWR VPWR sky130_fd_sc_hd__fill_1
X_584_ clknet_3_6__leaf_clk _036_ VGND VGND VPWR VPWR reg_array\[2\]\[12\] sky130_fd_sc_hd__dfxtp_1
XTAP_TAPCELL_ROW_32_210 VGND VPWR sky130_fd_sc_hd__tapvpwrvgnd_1
XFILLER_3_160 VGND VGND VPWR VPWR sky130_fd_sc_hd__decap_8
XFILLER_38_15 VPWR VGND VPWR VGND sky130_ef_sc_hd__decap_12
X_498_ net121 net25 net64 VGND VGND VPWR VPWR _064_ sky130_fd_sc_hd__mux2_1
XFILLER_28_81 VGND VGND VPWR VPWR sky130_fd_sc_hd__decap_3
X_567_ clknet_3_7__leaf_clk _019_ VGND VGND VPWR VPWR reg_array\[3\]\[11\] sky130_fd_sc_hd__dfxtp_1
X_636_ clknet_3_4__leaf_clk _088_ VGND VGND VPWR VPWR reg_array\[7\]\[0\] sky130_fd_sc_hd__dfxtp_1
X_421_ net7 net8 net10 net9 VGND VGND VPWR VPWR _247_ sky130_fd_sc_hd__and4bb_1
X_619_ clknet_3_3__leaf_clk _071_ VGND VGND VPWR VPWR reg_array\[6\]\[15\] sky130_fd_sc_hd__dfxtp_1
Xinput9 A3[2] VGND VGND VPWR VPWR net9 sky130_fd_sc_hd__clkbuf_1
XTAP_TAPCELL_ROW_1_86 VGND VPWR sky130_fd_sc_hd__tapvpwrvgnd_1
X_352_ reg_array\[1\]\[2\] net77 VGND VGND VPWR VPWR _192_ sky130_fd_sc_hd__and2_1
X_283_ reg_array\[4\]\[5\] reg_array\[5\]\[5\] reg_array\[6\]\[5\] reg_array\[7\]\[5\]
+ net97 net96 VGND VGND VPWR VPWR _136_ sky130_fd_sc_hd__mux4_1
XFILLER_27_148 VGND VGND VPWR VPWR sky130_fd_sc_hd__decap_4
X_404_ net86 _231_ _233_ net74 VGND VGND VPWR VPWR _234_ sky130_fd_sc_hd__a22o_1
X_266_ net94 _119_ net79 _122_ VGND VGND VPWR VPWR _123_ sky130_fd_sc_hd__a22o_1
X_335_ reg_array\[2\]\[15\] reg_array\[3\]\[15\] net98 VGND VGND VPWR VPWR _178_ sky130_fd_sc_hd__mux2_1
XFILLER_24_118 VGND VGND VPWR VPWR sky130_fd_sc_hd__decap_6
XPHY_EDGE_ROW_10_Right_10 VGND VGND VPWR VPWR sky130_fd_sc_hd__decap_3
XFILLER_2_53 VGND VGND VPWR VPWR sky130_fd_sc_hd__decap_3
XFILLER_23_162 VGND VGND VPWR VPWR sky130_fd_sc_hd__decap_6
XFILLER_36_81 VGND VGND VPWR VPWR sky130_fd_sc_hd__decap_3
X_318_ reg_array\[4\]\[12\] reg_array\[5\]\[12\] reg_array\[6\]\[12\] reg_array\[7\]\[12\]
+ net100 net2 VGND VGND VPWR VPWR _164_ sky130_fd_sc_hd__mux4_1
Xinput23 WD3[6] VGND VGND VPWR VPWR net23 sky130_fd_sc_hd__dlymetal6s2s_1
XPHY_EDGE_ROW_26_Left_65 VGND VGND VPWR VPWR sky130_fd_sc_hd__decap_3
XTAP_TAPCELL_ROW_16_146 VGND VPWR sky130_fd_sc_hd__tapvpwrvgnd_1
Xinput12 WD3[10] VGND VGND VPWR VPWR net12 sky130_fd_sc_hd__clkbuf_2
XPHY_EDGE_ROW_10_Left_49 VGND VGND VPWR VPWR sky130_fd_sc_hd__decap_3
XFILLER_22_83 VGND VGND VPWR VPWR sky130_fd_sc_hd__fill_1
XFILLER_14_7 VGND VGND VPWR VPWR sky130_fd_sc_hd__decap_8
XFILLER_7_125 VGND VGND VPWR VPWR sky130_fd_sc_hd__decap_4
XFILLER_7_169 VGND VGND VPWR VPWR sky130_fd_sc_hd__decap_4
XFILLER_8_85 VGND VGND VPWR VPWR sky130_fd_sc_hd__decap_3
X_583_ clknet_3_7__leaf_clk _035_ VGND VGND VPWR VPWR reg_array\[2\]\[11\] sky130_fd_sc_hd__dfxtp_1
XTAP_TAPCELL_ROW_32_211 VGND VPWR sky130_fd_sc_hd__tapvpwrvgnd_1
XPHY_EDGE_ROW_8_Right_8 VGND VGND VPWR VPWR sky130_fd_sc_hd__decap_3
Xhold1 reg_array\[1\]\[0\] VGND VGND VPWR VPWR net101 sky130_fd_sc_hd__dlygate4sd3_1
XFILLER_38_27 VGND VGND VPWR VPWR sky130_fd_sc_hd__fill_1
XPHY_EDGE_ROW_13_Left_52 VGND VGND VPWR VPWR sky130_fd_sc_hd__decap_3
X_635_ clknet_3_6__leaf_clk _087_ VGND VGND VPWR VPWR reg_array\[5\]\[15\] sky130_fd_sc_hd__dfxtp_1
X_566_ clknet_3_5__leaf_clk _018_ VGND VGND VPWR VPWR reg_array\[3\]\[10\] sky130_fd_sc_hd__dfxtp_1
X_497_ net175 net24 net63 VGND VGND VPWR VPWR _063_ sky130_fd_sc_hd__mux2_1
XFILLER_0_197 VPWR VGND VPWR VGND sky130_ef_sc_hd__decap_12
XFILLER_0_175 VPWR VGND VPWR VGND sky130_ef_sc_hd__decap_12
XFILLER_0_131 VGND VGND VPWR VPWR sky130_fd_sc_hd__decap_8
X_420_ _244_ _246_ net76 VGND VGND VPWR VPWR net49 sky130_fd_sc_hd__o21a_1
X_351_ reg_array\[4\]\[2\] reg_array\[5\]\[2\] reg_array\[6\]\[2\] reg_array\[7\]\[2\]
+ net89 net88 VGND VGND VPWR VPWR _191_ sky130_fd_sc_hd__mux4_1
XTAP_TAPCELL_ROW_1_87 VGND VPWR sky130_fd_sc_hd__tapvpwrvgnd_1
X_282_ _133_ _135_ net81 VGND VGND VPWR VPWR net37 sky130_fd_sc_hd__o21a_1
X_549_ clknet_3_2__leaf_clk _001_ VGND VGND VPWR VPWR reg_array\[4\]\[9\] sky130_fd_sc_hd__dfxtp_1
XFILLER_19_18 VGND VGND VPWR VPWR sky130_fd_sc_hd__decap_4
X_618_ clknet_3_4__leaf_clk _070_ VGND VGND VPWR VPWR reg_array\[6\]\[14\] sky130_fd_sc_hd__dfxtp_1
X_403_ reg_array\[2\]\[12\] reg_array\[3\]\[12\] net92 VGND VGND VPWR VPWR _233_ sky130_fd_sc_hd__mux2_1
XFILLER_26_193 VGND VGND VPWR VPWR sky130_fd_sc_hd__decap_3
X_334_ reg_array\[1\]\[15\] net84 VGND VGND VPWR VPWR _177_ sky130_fd_sc_hd__and2_1
X_265_ reg_array\[2\]\[1\] reg_array\[3\]\[1\] net100 VGND VGND VPWR VPWR _122_ sky130_fd_sc_hd__mux2_1
XFILLER_2_65 VGND VGND VPWR VPWR sky130_fd_sc_hd__fill_1
XTAP_TAPCELL_ROW_24_180 VGND VPWR sky130_fd_sc_hd__tapvpwrvgnd_1
Xinput13 WD3[11] VGND VGND VPWR VPWR net13 sky130_fd_sc_hd__dlymetal6s2s_1
X_317_ _161_ _163_ net82 VGND VGND VPWR VPWR net29 sky130_fd_sc_hd__o21a_1
XTAP_TAPCELL_ROW_16_147 VGND VPWR sky130_fd_sc_hd__tapvpwrvgnd_1
XFILLER_14_152 VGND VGND VPWR VPWR sky130_fd_sc_hd__fill_1
XFILLER_14_141 VGND VGND VPWR VPWR sky130_fd_sc_hd__decap_3
XFILLER_14_130 VGND VGND VPWR VPWR sky130_fd_sc_hd__decap_8
Xinput24 WD3[7] VGND VGND VPWR VPWR net24 sky130_fd_sc_hd__clkbuf_2
XFILLER_2_3 VPWR VGND VPWR VGND sky130_ef_sc_hd__decap_12
XPHY_EDGE_ROW_1_Left_40 VGND VGND VPWR VPWR sky130_fd_sc_hd__decap_3
XFILLER_32_29 VGND VGND VPWR VPWR sky130_fd_sc_hd__decap_3
X_651_ clknet_3_3__leaf_clk _103_ VGND VGND VPWR VPWR reg_array\[7\]\[15\] sky130_fd_sc_hd__dfxtp_1
X_582_ clknet_3_5__leaf_clk _034_ VGND VGND VPWR VPWR reg_array\[2\]\[10\] sky130_fd_sc_hd__dfxtp_1
Xhold2 reg_array\[1\]\[13\] VGND VGND VPWR VPWR net102 sky130_fd_sc_hd__dlygate4sd3_1
XTAP_TAPCELL_ROW_32_212 VGND VPWR sky130_fd_sc_hd__tapvpwrvgnd_1
XTAP_TAPCELL_ROW_4_98 VGND VPWR sky130_fd_sc_hd__tapvpwrvgnd_1
X_565_ clknet_3_3__leaf_clk _017_ VGND VGND VPWR VPWR reg_array\[3\]\[9\] sky130_fd_sc_hd__dfxtp_1
X_496_ net167 net23 net63 VGND VGND VPWR VPWR _062_ sky130_fd_sc_hd__mux2_1
X_634_ clknet_3_4__leaf_clk _086_ VGND VGND VPWR VPWR reg_array\[5\]\[14\] sky130_fd_sc_hd__dfxtp_1
XFILLER_0_187 VGND VGND VPWR VPWR sky130_fd_sc_hd__decap_8
XFILLER_5_65 VGND VGND VPWR VPWR sky130_fd_sc_hd__decap_3
X_350_ _188_ _190_ net75 VGND VGND VPWR VPWR net50 sky130_fd_sc_hd__o21a_1
XFILLER_14_85 VGND VGND VPWR VPWR sky130_fd_sc_hd__decap_4
XTAP_TAPCELL_ROW_1_88 VGND VPWR sky130_fd_sc_hd__tapvpwrvgnd_1
X_281_ net93 _132_ _134_ net79 VGND VGND VPWR VPWR _135_ sky130_fd_sc_hd__a22o_1
XFILLER_36_139 VGND VGND VPWR VPWR sky130_fd_sc_hd__fill_1
X_548_ clknet_3_7__leaf_clk _000_ VGND VGND VPWR VPWR reg_array\[4\]\[8\] sky130_fd_sc_hd__dfxtp_1
XFILLER_27_117 VGND VGND VPWR VPWR sky130_fd_sc_hd__fill_1
X_617_ clknet_3_3__leaf_clk _069_ VGND VGND VPWR VPWR reg_array\[6\]\[13\] sky130_fd_sc_hd__dfxtp_1
X_479_ net105 net23 net65 VGND VGND VPWR VPWR _046_ sky130_fd_sc_hd__mux2_1
XFILLER_33_109 VGND VGND VPWR VPWR sky130_fd_sc_hd__decap_3
XFILLER_18_139 VGND VGND VPWR VPWR sky130_fd_sc_hd__fill_1
X_402_ reg_array\[1\]\[12\] net78 VGND VGND VPWR VPWR _232_ sky130_fd_sc_hd__and2_1
X_333_ reg_array\[4\]\[15\] reg_array\[5\]\[15\] reg_array\[6\]\[15\] reg_array\[7\]\[15\]
+ net98 net96 VGND VGND VPWR VPWR _176_ sky130_fd_sc_hd__mux4_1
X_264_ net93 net95 VGND VGND VPWR VPWR _121_ sky130_fd_sc_hd__and2b_1
Xinput25 WD3[8] VGND VGND VPWR VPWR net25 sky130_fd_sc_hd__clkbuf_2
Xinput14 WD3[12] VGND VGND VPWR VPWR net14 sky130_fd_sc_hd__clkbuf_2
XTAP_TAPCELL_ROW_24_181 VGND VPWR sky130_fd_sc_hd__tapvpwrvgnd_1
X_316_ net94 _160_ _162_ net79 VGND VGND VPWR VPWR _163_ sky130_fd_sc_hd__a22o_1
XTAP_TAPCELL_ROW_16_148 VGND VPWR sky130_fd_sc_hd__tapvpwrvgnd_1
XFILLER_37_223 VGND VGND VPWR VPWR sky130_fd_sc_hd__fill_1
XTAP_TAPCELL_ROW_38_240 VGND VPWR sky130_fd_sc_hd__tapvpwrvgnd_1
XFILLER_22_63 VGND VGND VPWR VPWR sky130_fd_sc_hd__decap_4
XFILLER_8_21 VGND VGND VPWR VPWR sky130_fd_sc_hd__decap_6
X_650_ clknet_3_4__leaf_clk _102_ VGND VGND VPWR VPWR reg_array\[7\]\[14\] sky130_fd_sc_hd__dfxtp_1
X_581_ clknet_3_3__leaf_clk _033_ VGND VGND VPWR VPWR reg_array\[2\]\[9\] sky130_fd_sc_hd__dfxtp_1
Xhold3 reg_array\[1\]\[5\] VGND VGND VPWR VPWR net103 sky130_fd_sc_hd__dlygate4sd3_1
XTAP_TAPCELL_ROW_4_99 VGND VPWR sky130_fd_sc_hd__tapvpwrvgnd_1
XFILLER_38_29 VPWR VGND VPWR VGND sky130_ef_sc_hd__decap_12
XTAP_TAPCELL_ROW_32_213 VGND VPWR sky130_fd_sc_hd__tapvpwrvgnd_1
X_564_ clknet_3_7__leaf_clk _016_ VGND VGND VPWR VPWR reg_array\[3\]\[8\] sky130_fd_sc_hd__dfxtp_1
X_633_ clknet_3_3__leaf_clk _085_ VGND VGND VPWR VPWR reg_array\[5\]\[13\] sky130_fd_sc_hd__dfxtp_1
XFILLER_0_155 VGND VGND VPWR VPWR sky130_fd_sc_hd__fill_2
X_495_ net136 net22 net63 VGND VGND VPWR VPWR _061_ sky130_fd_sc_hd__mux2_1
XFILLER_5_99 VGND VGND VPWR VPWR sky130_fd_sc_hd__fill_1
XFILLER_10_3 VPWR VGND VPWR VGND sky130_ef_sc_hd__decap_12
XFILLER_38_181 VPWR VGND VPWR VGND sky130_ef_sc_hd__decap_12
X_280_ reg_array\[2\]\[4\] reg_array\[3\]\[4\] net99 VGND VGND VPWR VPWR _134_ sky130_fd_sc_hd__mux2_1
XFILLER_5_203 VGND VGND VPWR VPWR sky130_fd_sc_hd__fill_1
XFILLER_5_225 VGND VGND VPWR VPWR sky130_fd_sc_hd__fill_1
XFILLER_30_85 VGND VGND VPWR VPWR sky130_fd_sc_hd__decap_6
X_616_ clknet_3_6__leaf_clk _068_ VGND VGND VPWR VPWR reg_array\[6\]\[12\] sky130_fd_sc_hd__dfxtp_1
XTAP_TAPCELL_ROW_1_89 VGND VPWR sky130_fd_sc_hd__tapvpwrvgnd_1
X_478_ net103 net22 net65 VGND VGND VPWR VPWR _045_ sky130_fd_sc_hd__mux2_1
X_547_ clknet_3_1__leaf_clk _111_ VGND VGND VPWR VPWR reg_array\[4\]\[7\] sky130_fd_sc_hd__dfxtp_1
XFILLER_35_19 VPWR VGND VPWR VGND sky130_ef_sc_hd__decap_12
X_401_ reg_array\[4\]\[12\] reg_array\[5\]\[12\] reg_array\[6\]\[12\] reg_array\[7\]\[12\]
+ net92 net87 VGND VGND VPWR VPWR _231_ sky130_fd_sc_hd__mux4_1
X_263_ reg_array\[1\]\[1\] net83 VGND VGND VPWR VPWR _120_ sky130_fd_sc_hd__and2_1
X_332_ _173_ _175_ net81 VGND VGND VPWR VPWR net32 sky130_fd_sc_hd__o21a_1
XTAP_TAPCELL_ROW_27_190 VGND VPWR sky130_fd_sc_hd__tapvpwrvgnd_1
XTAP_TAPCELL_ROW_16_149 VGND VPWR sky130_fd_sc_hd__tapvpwrvgnd_1
Xinput15 WD3[13] VGND VGND VPWR VPWR net15 sky130_fd_sc_hd__dlymetal6s2s_1
Xinput26 WD3[9] VGND VGND VPWR VPWR net26 sky130_fd_sc_hd__dlymetal6s2s_1
X_315_ reg_array\[2\]\[11\] reg_array\[3\]\[11\] net100 VGND VGND VPWR VPWR _162_
+ sky130_fd_sc_hd__mux2_1
XFILLER_14_187 VGND VGND VPWR VPWR sky130_fd_sc_hd__fill_2
XTAP_TAPCELL_ROW_38_241 VGND VPWR sky130_fd_sc_hd__tapvpwrvgnd_1
XFILLER_11_146 VGND VGND VPWR VPWR sky130_fd_sc_hd__fill_2
XFILLER_11_135 VGND VGND VPWR VPWR sky130_fd_sc_hd__decap_3
XFILLER_34_205 VGND VGND VPWR VPWR sky130_fd_sc_hd__fill_2
XTAP_TAPCELL_ROW_12_130 VGND VPWR sky130_fd_sc_hd__tapvpwrvgnd_1
Xclkbuf_3_4__f_clk clknet_0_clk VGND VGND VPWR VPWR clknet_3_4__leaf_clk sky130_fd_sc_hd__clkbuf_16
XFILLER_8_11 VGND VGND VPWR VPWR sky130_fd_sc_hd__fill_1
XTAP_TAPCELL_ROW_35_222 VGND VPWR sky130_fd_sc_hd__tapvpwrvgnd_1
Xhold4 reg_array\[5\]\[8\] VGND VGND VPWR VPWR net104 sky130_fd_sc_hd__dlygate4sd3_1
XFILLER_33_52 VGND VGND VPWR VPWR sky130_fd_sc_hd__decap_4
X_580_ clknet_3_7__leaf_clk _032_ VGND VGND VPWR VPWR reg_array\[2\]\[8\] sky130_fd_sc_hd__dfxtp_1
XFILLER_17_42 VGND VGND VPWR VPWR sky130_fd_sc_hd__decap_8
XFILLER_16_227 VGND VGND VPWR VPWR sky130_fd_sc_hd__fill_2
XFILLER_3_120 VGND VGND VPWR VPWR sky130_fd_sc_hd__decap_6
XFILLER_12_7 VPWR VGND VPWR VGND sky130_ef_sc_hd__decap_12
XPHY_EDGE_ROW_26_Right_26 VGND VGND VPWR VPWR sky130_fd_sc_hd__decap_3
X_632_ clknet_3_6__leaf_clk _084_ VGND VGND VPWR VPWR reg_array\[5\]\[12\] sky130_fd_sc_hd__dfxtp_1
XPHY_EDGE_ROW_17_Right_17 VGND VGND VPWR VPWR sky130_fd_sc_hd__decap_3
XFILLER_13_219 VGND VGND VPWR VPWR sky130_fd_sc_hd__decap_4
XFILLER_0_167 VGND VGND VPWR VPWR sky130_fd_sc_hd__fill_1
X_563_ clknet_3_1__leaf_clk _015_ VGND VGND VPWR VPWR reg_array\[3\]\[7\] sky130_fd_sc_hd__dfxtp_1
XPHY_EDGE_ROW_35_Right_35 VGND VGND VPWR VPWR sky130_fd_sc_hd__decap_3
X_494_ net141 net21 net63 VGND VGND VPWR VPWR _060_ sky130_fd_sc_hd__mux2_1
XFILLER_38_193 VGND VGND VPWR VPWR sky130_fd_sc_hd__decap_3
XPHY_EDGE_ROW_17_Left_56 VGND VGND VPWR VPWR sky130_fd_sc_hd__decap_3
XFILLER_36_119 VPWR VGND VPWR VGND sky130_ef_sc_hd__decap_12
XFILLER_29_160 VGND VGND VPWR VPWR sky130_fd_sc_hd__decap_8
X_546_ clknet_3_2__leaf_clk _110_ VGND VGND VPWR VPWR reg_array\[4\]\[6\] sky130_fd_sc_hd__dfxtp_1
X_615_ clknet_3_6__leaf_clk _067_ VGND VGND VPWR VPWR reg_array\[6\]\[11\] sky130_fd_sc_hd__dfxtp_1
X_477_ net109 net21 net65 VGND VGND VPWR VPWR _044_ sky130_fd_sc_hd__mux2_1
XFILLER_35_185 VPWR VGND VPWR VGND sky130_ef_sc_hd__decap_12
XFILLER_27_108 VGND VGND VPWR VPWR sky130_fd_sc_hd__decap_4
X_262_ reg_array\[4\]\[1\] reg_array\[5\]\[1\] reg_array\[6\]\[1\] reg_array\[7\]\[1\]
+ net99 net95 VGND VGND VPWR VPWR _119_ sky130_fd_sc_hd__mux4_1
XFILLER_26_141 VGND VGND VPWR VPWR sky130_fd_sc_hd__fill_1
X_400_ _228_ _230_ net76 VGND VGND VPWR VPWR net45 sky130_fd_sc_hd__o21a_1
X_331_ net94 _172_ _174_ net79 VGND VGND VPWR VPWR _175_ sky130_fd_sc_hd__a22o_1
XFILLER_32_133 VGND VGND VPWR VPWR sky130_fd_sc_hd__decap_3
XFILLER_32_111 VGND VGND VPWR VPWR sky130_fd_sc_hd__decap_6
XTAP_TAPCELL_ROW_27_191 VGND VPWR sky130_fd_sc_hd__tapvpwrvgnd_1
XTAP_TAPCELL_ROW_19_158 VGND VPWR sky130_fd_sc_hd__tapvpwrvgnd_1
X_529_ net146 net22 net59 VGND VGND VPWR VPWR _093_ sky130_fd_sc_hd__mux2_1
XFILLER_23_133 VGND VGND VPWR VPWR sky130_fd_sc_hd__fill_1
XFILLER_11_55 VGND VGND VPWR VPWR sky130_fd_sc_hd__fill_1
XFILLER_11_11 VGND VGND VPWR VPWR sky130_fd_sc_hd__fill_2
XFILLER_37_225 VGND VGND VPWR VPWR sky130_fd_sc_hd__decap_4
XFILLER_36_85 VGND VGND VPWR VPWR sky130_fd_sc_hd__decap_4
XFILLER_36_41 VGND VGND VPWR VPWR sky130_fd_sc_hd__decap_8
X_314_ reg_array\[1\]\[11\] net84 VGND VGND VPWR VPWR _161_ sky130_fd_sc_hd__and2_1
Xinput16 WD3[14] VGND VGND VPWR VPWR net16 sky130_fd_sc_hd__dlymetal6s2s_1
XFILLER_28_203 VGND VGND VPWR VPWR sky130_fd_sc_hd__fill_1
XTAP_TAPCELL_ROW_12_131 VGND VPWR sky130_fd_sc_hd__tapvpwrvgnd_1
XFILLER_0_3 VPWR VGND VPWR VGND sky130_ef_sc_hd__decap_12
XPHY_EDGE_ROW_5_Left_44 VGND VGND VPWR VPWR sky130_fd_sc_hd__decap_3
XFILLER_7_107 VGND VGND VPWR VPWR sky130_fd_sc_hd__decap_4
XFILLER_8_45 VGND VGND VPWR VPWR sky130_fd_sc_hd__decap_4
XTAP_TAPCELL_ROW_35_223 VGND VPWR sky130_fd_sc_hd__tapvpwrvgnd_1
XFILLER_33_3 VPWR VGND VPWR VGND sky130_ef_sc_hd__decap_12
XFILLER_17_98 VGND VGND VPWR VPWR sky130_fd_sc_hd__decap_6
Xhold5 reg_array\[1\]\[6\] VGND VGND VPWR VPWR net105 sky130_fd_sc_hd__dlygate4sd3_1
XFILLER_0_113 VGND VGND VPWR VPWR sky130_fd_sc_hd__fill_2
XFILLER_28_64 VGND VGND VPWR VPWR sky130_fd_sc_hd__fill_1
X_631_ clknet_3_6__leaf_clk _083_ VGND VGND VPWR VPWR reg_array\[5\]\[11\] sky130_fd_sc_hd__dfxtp_1
X_562_ clknet_3_2__leaf_clk _014_ VGND VGND VPWR VPWR reg_array\[3\]\[6\] sky130_fd_sc_hd__dfxtp_1
X_493_ net147 net20 net63 VGND VGND VPWR VPWR _059_ sky130_fd_sc_hd__mux2_1
XFILLER_5_46 VGND VGND VPWR VPWR sky130_fd_sc_hd__fill_1
XFILLER_5_57 VGND VGND VPWR VPWR sky130_fd_sc_hd__decap_8
XFILLER_38_161 VGND VGND VPWR VPWR sky130_fd_sc_hd__decap_6
XPHY_EDGE_ROW_34_Left_73 VGND VGND VPWR VPWR sky130_fd_sc_hd__decap_3
X_476_ net149 net20 net65 VGND VGND VPWR VPWR _043_ sky130_fd_sc_hd__mux2_1
X_614_ clknet_3_4__leaf_clk _066_ VGND VGND VPWR VPWR reg_array\[6\]\[10\] sky130_fd_sc_hd__dfxtp_1
X_545_ clknet_3_0__leaf_clk _109_ VGND VGND VPWR VPWR reg_array\[4\]\[5\] sky130_fd_sc_hd__dfxtp_1
XFILLER_35_197 VGND VGND VPWR VPWR sky130_fd_sc_hd__decap_6
XFILLER_35_131 VGND VGND VPWR VPWR sky130_fd_sc_hd__decap_6
X_330_ reg_array\[2\]\[14\] reg_array\[3\]\[14\] net99 VGND VGND VPWR VPWR _174_ sky130_fd_sc_hd__mux2_1
X_261_ _115_ _118_ net81 VGND VGND VPWR VPWR net27 sky130_fd_sc_hd__o21a_1
XFILLER_32_167 VGND VGND VPWR VPWR sky130_fd_sc_hd__fill_1
XTAP_TAPCELL_ROW_27_192 VGND VPWR sky130_fd_sc_hd__tapvpwrvgnd_1
XTAP_TAPCELL_ROW_19_159 VGND VPWR sky130_fd_sc_hd__tapvpwrvgnd_1
X_459_ net178 net20 net67 VGND VGND VPWR VPWR _027_ sky130_fd_sc_hd__mux2_1
XTAP_TAPCELL_ROW_2_90 VGND VPWR sky130_fd_sc_hd__tapvpwrvgnd_1
X_528_ net145 net21 net59 VGND VGND VPWR VPWR _092_ sky130_fd_sc_hd__mux2_1
XFILLER_11_45 VGND VGND VPWR VPWR sky130_fd_sc_hd__fill_1
XFILLER_35_7 VPWR VGND VPWR VGND sky130_ef_sc_hd__decap_12
Xinput17 WD3[15] VGND VGND VPWR VPWR net17 sky130_fd_sc_hd__clkbuf_2
X_313_ reg_array\[4\]\[11\] reg_array\[5\]\[11\] reg_array\[6\]\[11\] reg_array\[7\]\[11\]
+ net100 net95 VGND VGND VPWR VPWR _160_ sky130_fd_sc_hd__mux4_1
XFILLER_28_226 VGND VGND VPWR VPWR sky130_fd_sc_hd__decap_3
XPHY_EDGE_ROW_21_Left_60 VGND VGND VPWR VPWR sky130_fd_sc_hd__decap_3
XFILLER_20_126 VPWR VGND VPWR VGND sky130_ef_sc_hd__decap_12
XFILLER_19_204 VGND VGND VPWR VPWR sky130_fd_sc_hd__decap_4
XFILLER_11_126 VGND VGND VPWR VPWR sky130_fd_sc_hd__fill_1
XTAP_TAPCELL_ROW_35_224 VGND VPWR sky130_fd_sc_hd__tapvpwrvgnd_1
XTAP_TAPCELL_ROW_12_132 VGND VPWR sky130_fd_sc_hd__tapvpwrvgnd_1
XFILLER_6_141 VGND VGND VPWR VPWR sky130_fd_sc_hd__fill_2
XFILLER_33_87 VGND VGND VPWR VPWR sky130_fd_sc_hd__decap_4
XFILLER_33_32 VGND VGND VPWR VPWR sky130_fd_sc_hd__decap_3
Xhold6 reg_array\[5\]\[9\] VGND VGND VPWR VPWR net106 sky130_fd_sc_hd__dlygate4sd3_1
XFILLER_3_111 VGND VGND VPWR VPWR sky130_fd_sc_hd__fill_1
XFILLER_0_91 VGND VGND VPWR VPWR sky130_fd_sc_hd__decap_3
XPHY_EDGE_ROW_3_Right_3 VGND VGND VPWR VPWR sky130_fd_sc_hd__decap_3
X_492_ net127 net19 net63 VGND VGND VPWR VPWR _058_ sky130_fd_sc_hd__mux2_1
X_630_ clknet_3_4__leaf_clk _082_ VGND VGND VPWR VPWR reg_array\[5\]\[10\] sky130_fd_sc_hd__dfxtp_1
XFILLER_0_169 VGND VGND VPWR VPWR sky130_fd_sc_hd__fill_2
X_561_ clknet_3_0__leaf_clk _013_ VGND VGND VPWR VPWR reg_array\[3\]\[5\] sky130_fd_sc_hd__dfxtp_1
X_613_ clknet_3_2__leaf_clk _065_ VGND VGND VPWR VPWR reg_array\[6\]\[9\] sky130_fd_sc_hd__dfxtp_1
XFILLER_14_89 VGND VGND VPWR VPWR sky130_fd_sc_hd__fill_1
X_475_ net110 net19 net65 VGND VGND VPWR VPWR _042_ sky130_fd_sc_hd__mux2_1
X_544_ clknet_3_4__leaf_clk _108_ VGND VGND VPWR VPWR reg_array\[4\]\[4\] sky130_fd_sc_hd__dfxtp_1
XFILLER_26_110 VGND VGND VPWR VPWR sky130_fd_sc_hd__fill_1
XFILLER_25_66 VGND VGND VPWR VPWR sky130_fd_sc_hd__fill_2
XFILLER_2_209 VPWR VGND VPWR VGND sky130_ef_sc_hd__decap_12
X_260_ net95 _114_ _116_ _117_ VGND VGND VPWR VPWR _118_ sky130_fd_sc_hd__a22o_1
X_389_ net85 _219_ _221_ net73 VGND VGND VPWR VPWR _222_ sky130_fd_sc_hd__a22o_1
XFILLER_32_157 VGND VGND VPWR VPWR sky130_fd_sc_hd__fill_1
XTAP_TAPCELL_ROW_27_193 VGND VPWR sky130_fd_sc_hd__tapvpwrvgnd_1
X_527_ net163 net20 net59 VGND VGND VPWR VPWR _091_ sky130_fd_sc_hd__mux2_1
XFILLER_17_143 VGND VGND VPWR VPWR sky130_fd_sc_hd__decap_4
XFILLER_2_15 VPWR VGND VPWR VGND sky130_ef_sc_hd__decap_12
X_458_ net137 net19 net67 VGND VGND VPWR VPWR _026_ sky130_fd_sc_hd__mux2_1
XTAP_TAPCELL_ROW_2_91 VGND VPWR sky130_fd_sc_hd__tapvpwrvgnd_1
Xinput18 WD3[1] VGND VGND VPWR VPWR net18 sky130_fd_sc_hd__dlymetal6s2s_1
X_312_ _157_ _159_ net81 VGND VGND VPWR VPWR net28 sky130_fd_sc_hd__o21a_1
XFILLER_37_205 VPWR VGND VPWR VGND sky130_ef_sc_hd__decap_12
XFILLER_28_7 VGND VGND VPWR VPWR sky130_fd_sc_hd__fill_2
XFILLER_20_138 VGND VGND VPWR VPWR sky130_fd_sc_hd__fill_2
XTAP_TAPCELL_ROW_29_200 VGND VPWR sky130_fd_sc_hd__tapvpwrvgnd_1
XFILLER_22_67 VGND VGND VPWR VPWR sky130_fd_sc_hd__fill_1
XTAP_TAPCELL_ROW_21_166 VGND VPWR sky130_fd_sc_hd__tapvpwrvgnd_1
XTAP_TAPCELL_ROW_12_133 VGND VPWR sky130_fd_sc_hd__tapvpwrvgnd_1
XTAP_TAPCELL_ROW_35_225 VGND VPWR sky130_fd_sc_hd__tapvpwrvgnd_1
XFILLER_33_44 VGND VGND VPWR VPWR sky130_fd_sc_hd__fill_2
Xhold7 reg_array\[5\]\[15\] VGND VGND VPWR VPWR net107 sky130_fd_sc_hd__dlygate4sd3_1
XFILLER_9_90 VGND VGND VPWR VPWR sky130_fd_sc_hd__fill_2
XFILLER_28_33 VGND VGND VPWR VPWR sky130_fd_sc_hd__fill_1
X_491_ net169 net18 net64 VGND VGND VPWR VPWR _057_ sky130_fd_sc_hd__mux2_1
X_560_ clknet_3_4__leaf_clk _012_ VGND VGND VPWR VPWR reg_array\[3\]\[4\] sky130_fd_sc_hd__dfxtp_1
XFILLER_5_15 VGND VGND VPWR VPWR sky130_fd_sc_hd__fill_1
XFILLER_8_204 VGND VGND VPWR VPWR sky130_fd_sc_hd__decap_3
XPHY_EDGE_ROW_22_Right_22 VGND VGND VPWR VPWR sky130_fd_sc_hd__decap_3
XPHY_EDGE_ROW_13_Right_13 VGND VGND VPWR VPWR sky130_fd_sc_hd__decap_3
XFILLER_38_141 VGND VGND VPWR VPWR sky130_fd_sc_hd__fill_2
XPHY_EDGE_ROW_31_Right_31 VGND VGND VPWR VPWR sky130_fd_sc_hd__decap_3
X_612_ clknet_3_6__leaf_clk _064_ VGND VGND VPWR VPWR reg_array\[6\]\[8\] sky130_fd_sc_hd__dfxtp_1
X_474_ net180 net18 net66 VGND VGND VPWR VPWR _041_ sky130_fd_sc_hd__mux2_1
X_543_ clknet_3_1__leaf_clk _107_ VGND VGND VPWR VPWR reg_array\[4\]\[3\] sky130_fd_sc_hd__dfxtp_1
XFILLER_35_166 VGND VGND VPWR VPWR sky130_fd_sc_hd__fill_2
X_526_ net115 net19 net59 VGND VGND VPWR VPWR _090_ sky130_fd_sc_hd__mux2_1
XFILLER_2_27 VGND VGND VPWR VPWR sky130_fd_sc_hd__fill_1
X_388_ reg_array\[2\]\[9\] reg_array\[3\]\[9\] net90 VGND VGND VPWR VPWR _221_ sky130_fd_sc_hd__mux2_1
X_457_ net172 net18 net67 VGND VGND VPWR VPWR _025_ sky130_fd_sc_hd__mux2_1
XTAP_TAPCELL_ROW_2_92 VGND VPWR sky130_fd_sc_hd__tapvpwrvgnd_1
X_311_ net94 _156_ _158_ net79 VGND VGND VPWR VPWR _159_ sky130_fd_sc_hd__a22o_1
Xinput19 WD3[2] VGND VGND VPWR VPWR net19 sky130_fd_sc_hd__dlymetal6s2s_1
XFILLER_37_217 VGND VGND VPWR VPWR sky130_fd_sc_hd__decap_6
X_509_ net196 net19 net61 VGND VGND VPWR VPWR _074_ sky130_fd_sc_hd__mux2_1
XTAP_TAPCELL_ROW_15_142 VGND VPWR sky130_fd_sc_hd__tapvpwrvgnd_1
XTAP_TAPCELL_ROW_38_234 VGND VPWR sky130_fd_sc_hd__tapvpwrvgnd_1
XFILLER_22_35 VGND VGND VPWR VPWR sky130_fd_sc_hd__decap_4
XTAP_TAPCELL_ROW_21_167 VGND VPWR sky130_fd_sc_hd__tapvpwrvgnd_1
XTAP_TAPCELL_ROW_29_201 VGND VPWR sky130_fd_sc_hd__tapvpwrvgnd_1
XFILLER_10_150 VGND VGND VPWR VPWR sky130_fd_sc_hd__fill_1
XFILLER_8_59 VGND VGND VPWR VPWR sky130_fd_sc_hd__fill_1
Xhold8 reg_array\[7\]\[15\] VGND VGND VPWR VPWR net108 sky130_fd_sc_hd__dlygate4sd3_1
XFILLER_3_113 VGND VGND VPWR VPWR sky130_fd_sc_hd__fill_2
XPHY_EDGE_ROW_9_Left_48 VGND VGND VPWR VPWR sky130_fd_sc_hd__decap_3
X_490_ net134 net11 net63 VGND VGND VPWR VPWR _056_ sky130_fd_sc_hd__mux2_1
XFILLER_38_197 VGND VGND VPWR VPWR sky130_fd_sc_hd__fill_2
XFILLER_38_131 VGND VGND VPWR VPWR sky130_fd_sc_hd__decap_8
XFILLER_30_57 VGND VGND VPWR VPWR sky130_fd_sc_hd__decap_3
XFILLER_30_24 VGND VGND VPWR VPWR sky130_fd_sc_hd__decap_4
X_542_ clknet_3_4__leaf_clk _106_ VGND VGND VPWR VPWR reg_array\[4\]\[2\] sky130_fd_sc_hd__dfxtp_1
X_473_ net101 net11 net65 VGND VGND VPWR VPWR _040_ sky130_fd_sc_hd__mux2_1
X_611_ clknet_3_0__leaf_clk _063_ VGND VGND VPWR VPWR reg_array\[6\]\[7\] sky130_fd_sc_hd__dfxtp_1
XPHY_EDGE_ROW_38_Left_77 VGND VGND VPWR VPWR sky130_fd_sc_hd__decap_3
XFILLER_9_3 VPWR VGND VPWR VGND sky130_ef_sc_hd__decap_12
X_387_ reg_array\[1\]\[9\] net78 VGND VGND VPWR VPWR _220_ sky130_fd_sc_hd__and2_1
X_525_ net164 net18 net60 VGND VGND VPWR VPWR _089_ sky130_fd_sc_hd__mux2_1
XFILLER_17_178 VGND VGND VPWR VPWR sky130_fd_sc_hd__fill_1
XTAP_TAPCELL_ROW_2_93 VGND VPWR sky130_fd_sc_hd__tapvpwrvgnd_1
X_456_ net162 net11 net68 VGND VGND VPWR VPWR _024_ sky130_fd_sc_hd__mux2_1
X_310_ reg_array\[2\]\[10\] reg_array\[3\]\[10\] net99 VGND VGND VPWR VPWR _158_ sky130_fd_sc_hd__mux2_1
X_508_ net189 net18 net62 VGND VGND VPWR VPWR _073_ sky130_fd_sc_hd__mux2_1
XTAP_TAPCELL_ROW_15_143 VGND VPWR sky130_fd_sc_hd__tapvpwrvgnd_1
X_439_ net184 net11 net69 VGND VGND VPWR VPWR _008_ sky130_fd_sc_hd__mux2_1
XTAP_TAPCELL_ROW_38_235 VGND VPWR sky130_fd_sc_hd__tapvpwrvgnd_1
XTAP_TAPCELL_ROW_21_168 VGND VPWR sky130_fd_sc_hd__tapvpwrvgnd_1
XFILLER_8_27 VGND VGND VPWR VPWR sky130_fd_sc_hd__fill_1
XFILLER_8_49 VGND VGND VPWR VPWR sky130_fd_sc_hd__fill_1
XPHY_EDGE_ROW_25_Left_64 VGND VGND VPWR VPWR sky130_fd_sc_hd__decap_3
XFILLER_33_57 VGND VGND VPWR VPWR sky130_fd_sc_hd__decap_6
Xhold9 reg_array\[1\]\[4\] VGND VGND VPWR VPWR net109 sky130_fd_sc_hd__dlygate4sd3_1
XFILLER_3_169 VPWR VGND VPWR VGND sky130_ef_sc_hd__decap_12
XFILLER_0_139 VGND VGND VPWR VPWR sky130_fd_sc_hd__fill_1
XFILLER_38_154 VGND VGND VPWR VPWR sky130_fd_sc_hd__decap_3
XFILLER_14_26 VGND VGND VPWR VPWR sky130_fd_sc_hd__fill_2
XFILLER_14_15 VGND VGND VPWR VPWR sky130_fd_sc_hd__decap_3
XPHY_EDGE_ROW_7_Right_7 VGND VGND VPWR VPWR sky130_fd_sc_hd__decap_3
X_541_ clknet_3_7__leaf_clk _105_ VGND VGND VPWR VPWR reg_array\[4\]\[1\] sky130_fd_sc_hd__dfxtp_1
X_610_ clknet_3_2__leaf_clk _062_ VGND VGND VPWR VPWR reg_array\[6\]\[6\] sky130_fd_sc_hd__dfxtp_1
X_472_ net9 net8 net10 net7 VGND VGND VPWR VPWR _250_ sky130_fd_sc_hd__and4bb_1
XPHY_EDGE_ROW_12_Left_51 VGND VGND VPWR VPWR sky130_fd_sc_hd__decap_3
XFILLER_20_80 VGND VGND VPWR VPWR sky130_fd_sc_hd__decap_4
XFILLER_26_168 VGND VGND VPWR VPWR sky130_fd_sc_hd__decap_4
XFILLER_1_223 VGND VGND VPWR VPWR sky130_fd_sc_hd__fill_1
X_386_ reg_array\[4\]\[9\] reg_array\[5\]\[9\] reg_array\[6\]\[9\] reg_array\[7\]\[9\]
+ net90 net88 VGND VGND VPWR VPWR _219_ sky130_fd_sc_hd__mux4_1
X_455_ net7 net9 net8 net10 VGND VGND VPWR VPWR _249_ sky130_fd_sc_hd__and4bb_1
XFILLER_17_124 VGND VGND VPWR VPWR sky130_fd_sc_hd__decap_3
XFILLER_2_29 VPWR VGND VPWR VGND sky130_ef_sc_hd__decap_12
X_524_ net131 net11 net59 VGND VGND VPWR VPWR _088_ sky130_fd_sc_hd__mux2_1
XFILLER_14_138 VGND VGND VPWR VPWR sky130_fd_sc_hd__fill_2
XTAP_TAPCELL_ROW_9_120 VGND VPWR sky130_fd_sc_hd__tapvpwrvgnd_1
XTAP_TAPCELL_ROW_38_236 VGND VPWR sky130_fd_sc_hd__tapvpwrvgnd_1
X_438_ net9 net8 net10 net7 VGND VGND VPWR VPWR _248_ sky130_fd_sc_hd__and4b_1
XTAP_TAPCELL_ROW_15_144 VGND VPWR sky130_fd_sc_hd__tapvpwrvgnd_1
XFILLER_11_108 VGND VGND VPWR VPWR sky130_fd_sc_hd__decap_4
X_369_ net85 _203_ _205_ net73 VGND VGND VPWR VPWR _206_ sky130_fd_sc_hd__a22o_1
X_507_ net193 net11 net61 VGND VGND VPWR VPWR _072_ sky130_fd_sc_hd__mux2_1
XTAP_TAPCELL_ROW_21_169 VGND VPWR sky130_fd_sc_hd__tapvpwrvgnd_1
XFILLER_19_6 VPWR VGND VPWR VGND sky130_ef_sc_hd__decap_12
XFILLER_3_126 VGND VGND VPWR VPWR sky130_fd_sc_hd__fill_1
XFILLER_28_25 VGND VGND VPWR VPWR sky130_fd_sc_hd__decap_3
Xclkbuf_3_5__f_clk clknet_0_clk VGND VGND VPWR VPWR clknet_3_5__leaf_clk sky130_fd_sc_hd__clkbuf_16
X_471_ net161 net17 net67 VGND VGND VPWR VPWR _039_ sky130_fd_sc_hd__mux2_1
X_540_ clknet_3_5__leaf_clk _104_ VGND VGND VPWR VPWR reg_array\[4\]\[0\] sky130_fd_sc_hd__dfxtp_1
XFILLER_35_158 VGND VGND VPWR VPWR sky130_fd_sc_hd__decap_8
XFILLER_35_103 VGND VGND VPWR VPWR sky130_fd_sc_hd__decap_4
XFILLER_20_70 VGND VGND VPWR VPWR sky130_fd_sc_hd__fill_2
Xhold90 reg_array\[3\]\[15\] VGND VGND VPWR VPWR net190 sky130_fd_sc_hd__dlygate4sd3_1
XFILLER_26_136 VGND VGND VPWR VPWR sky130_fd_sc_hd__decap_4
XFILLER_25_37 VGND VGND VPWR VPWR sky130_fd_sc_hd__decap_4
XFILLER_6_83 VGND VGND VPWR VPWR sky130_fd_sc_hd__fill_1
X_385_ _216_ _218_ net76 VGND VGND VPWR VPWR net57 sky130_fd_sc_hd__o21a_1
X_523_ net7 net9 net8 net10 VGND VGND VPWR VPWR _253_ sky130_fd_sc_hd__and4_1
X_454_ net190 net17 net69 VGND VGND VPWR VPWR _023_ sky130_fd_sc_hd__mux2_1
XFILLER_31_150 VGND VGND VPWR VPWR sky130_fd_sc_hd__fill_1
XFILLER_23_117 VPWR VGND VPWR VGND sky130_ef_sc_hd__decap_12
XTAP_TAPCELL_ROW_24_178 VGND VPWR sky130_fd_sc_hd__tapvpwrvgnd_1
XFILLER_22_183 VGND VGND VPWR VPWR sky130_fd_sc_hd__decap_3
XFILLER_22_150 VGND VGND VPWR VPWR sky130_fd_sc_hd__decap_3
XTAP_TAPCELL_ROW_9_121 VGND VPWR sky130_fd_sc_hd__tapvpwrvgnd_1
XTAP_TAPCELL_ROW_38_237 VGND VPWR sky130_fd_sc_hd__tapvpwrvgnd_1
X_299_ reg_array\[1\]\[8\] net84 VGND VGND VPWR VPWR _149_ sky130_fd_sc_hd__and2_1
X_506_ net8 net10 net7 net9 VGND VGND VPWR VPWR _252_ sky130_fd_sc_hd__and4b_1
X_437_ net153 net17 net72 VGND VGND VPWR VPWR _007_ sky130_fd_sc_hd__mux2_1
XTAP_TAPCELL_ROW_15_145 VGND VPWR sky130_fd_sc_hd__tapvpwrvgnd_1
X_368_ reg_array\[2\]\[5\] reg_array\[3\]\[5\] net89 VGND VGND VPWR VPWR _205_ sky130_fd_sc_hd__mux2_1
Xfanout100 net1 VGND VGND VPWR VPWR net100 sky130_fd_sc_hd__buf_2
XPHY_EDGE_ROW_29_Right_29 VGND VGND VPWR VPWR sky130_fd_sc_hd__decap_3
XFILLER_22_27 VGND VGND VPWR VPWR sky130_fd_sc_hd__fill_1
XPHY_EDGE_ROW_38_Right_38 VGND VGND VPWR VPWR sky130_fd_sc_hd__decap_3
XFILLER_33_212 VGND VGND VPWR VPWR sky130_fd_sc_hd__fill_1
XFILLER_10_186 VGND VGND VPWR VPWR sky130_fd_sc_hd__decap_4
XFILLER_10_175 VGND VGND VPWR VPWR sky130_fd_sc_hd__decap_3
XFILLER_6_157 VGND VGND VPWR VPWR sky130_fd_sc_hd__fill_2
XFILLER_31_6 VGND VGND VPWR VPWR sky130_fd_sc_hd__fill_2
XFILLER_0_74 VGND VGND VPWR VPWR sky130_fd_sc_hd__fill_2
XFILLER_0_41 VGND VGND VPWR VPWR sky130_fd_sc_hd__decap_4
XFILLER_0_119 VPWR VGND VPWR VGND sky130_ef_sc_hd__decap_12
XFILLER_38_167 VGND VGND VPWR VPWR sky130_fd_sc_hd__fill_1
XFILLER_29_178 VGND VGND VPWR VPWR sky130_fd_sc_hd__fill_1
XFILLER_14_39 VGND VGND VPWR VPWR sky130_fd_sc_hd__decap_3
Xhold80 reg_array\[1\]\[1\] VGND VGND VPWR VPWR net180 sky130_fd_sc_hd__dlygate4sd3_1
X_599_ clknet_3_7__leaf_clk _051_ VGND VGND VPWR VPWR reg_array\[1\]\[11\] sky130_fd_sc_hd__dfxtp_1
X_470_ net116 net16 net68 VGND VGND VPWR VPWR _038_ sky130_fd_sc_hd__mux2_1
Xhold91 reg_array\[4\]\[3\] VGND VGND VPWR VPWR net191 sky130_fd_sc_hd__dlygate4sd3_1
X_384_ net86 _215_ _217_ net73 VGND VGND VPWR VPWR _218_ sky130_fd_sc_hd__a22o_1
X_522_ net107 net17 net62 VGND VGND VPWR VPWR _087_ sky130_fd_sc_hd__mux2_1
X_453_ net185 net16 net69 VGND VGND VPWR VPWR _022_ sky130_fd_sc_hd__mux2_1
XFILLER_1_225 VGND VGND VPWR VPWR sky130_fd_sc_hd__decap_4
XFILLER_23_129 VGND VGND VPWR VPWR sky130_fd_sc_hd__decap_4
XTAP_TAPCELL_ROW_18_154 VGND VPWR sky130_fd_sc_hd__tapvpwrvgnd_1
XFILLER_36_15 VPWR VGND VPWR VGND sky130_ef_sc_hd__decap_12
XTAP_TAPCELL_ROW_24_179 VGND VPWR sky130_fd_sc_hd__tapvpwrvgnd_1
XFILLER_22_195 VGND VGND VPWR VPWR sky130_fd_sc_hd__fill_1
X_298_ reg_array\[4\]\[8\] reg_array\[5\]\[8\] reg_array\[6\]\[8\] reg_array\[7\]\[8\]
+ net100 net95 VGND VGND VPWR VPWR _148_ sky130_fd_sc_hd__mux4_1
X_505_ net112 net17 net63 VGND VGND VPWR VPWR _071_ sky130_fd_sc_hd__mux2_1
X_436_ net143 net16 net72 VGND VGND VPWR VPWR _006_ sky130_fd_sc_hd__mux2_1
X_367_ reg_array\[1\]\[5\] net77 VGND VGND VPWR VPWR _204_ sky130_fd_sc_hd__and2_1
XFILLER_3_52 VGND VGND VPWR VPWR sky130_fd_sc_hd__decap_4
XTAP_TAPCELL_ROW_38_238 VGND VPWR sky130_fd_sc_hd__tapvpwrvgnd_1
XFILLER_36_221 VGND VGND VPWR VPWR sky130_fd_sc_hd__decap_8
XFILLER_37_91 VGND VGND VPWR VPWR sky130_fd_sc_hd__decap_8
X_419_ net86 _243_ _245_ net73 VGND VGND VPWR VPWR _246_ sky130_fd_sc_hd__a22o_1
XFILLER_30_227 VGND VGND VPWR VPWR sky130_fd_sc_hd__fill_2
XFILLER_30_216 VGND VGND VPWR VPWR sky130_fd_sc_hd__decap_4
XFILLER_15_213 VGND VGND VPWR VPWR sky130_fd_sc_hd__fill_1
XPHY_EDGE_ROW_29_Left_68 VGND VGND VPWR VPWR sky130_fd_sc_hd__decap_3
XFILLER_34_81 VGND VGND VPWR VPWR sky130_fd_sc_hd__decap_3
XFILLER_18_71 VGND VGND VPWR VPWR sky130_fd_sc_hd__decap_4
XFILLER_38_113 VGND VGND VPWR VPWR sky130_fd_sc_hd__fill_2
XFILLER_14_29 VGND VGND VPWR VPWR sky130_fd_sc_hd__fill_1
XFILLER_29_113 VPWR VGND VPWR VGND sky130_ef_sc_hd__decap_12
Xhold70 reg_array\[4\]\[2\] VGND VGND VPWR VPWR net170 sky130_fd_sc_hd__dlygate4sd3_1
Xhold92 reg_array\[3\]\[2\] VGND VGND VPWR VPWR net192 sky130_fd_sc_hd__dlygate4sd3_1
Xhold81 reg_array\[4\]\[5\] VGND VGND VPWR VPWR net181 sky130_fd_sc_hd__dlygate4sd3_1
XPHY_EDGE_ROW_16_Left_55 VGND VGND VPWR VPWR sky130_fd_sc_hd__decap_3
X_598_ clknet_3_5__leaf_clk _050_ VGND VGND VPWR VPWR reg_array\[1\]\[10\] sky130_fd_sc_hd__dfxtp_1
XFILLER_6_85 VPWR VGND VPWR VGND sky130_ef_sc_hd__decap_12
XFILLER_34_193 VGND VGND VPWR VPWR sky130_fd_sc_hd__decap_3
X_452_ net203 net15 net70 VGND VGND VPWR VPWR _021_ sky130_fd_sc_hd__mux2_1
X_383_ reg_array\[2\]\[8\] reg_array\[3\]\[8\] net92 VGND VGND VPWR VPWR _217_ sky130_fd_sc_hd__mux2_1
X_521_ net130 net16 net61 VGND VGND VPWR VPWR _086_ sky130_fd_sc_hd__mux2_1
XTAP_TAPCELL_ROW_18_155 VGND VPWR sky130_fd_sc_hd__tapvpwrvgnd_1
XFILLER_36_49 VGND VGND VPWR VPWR sky130_fd_sc_hd__fill_2
XFILLER_36_27 VGND VGND VPWR VPWR sky130_fd_sc_hd__fill_1
X_435_ net195 net15 net71 VGND VGND VPWR VPWR _005_ sky130_fd_sc_hd__mux2_1
X_504_ net157 net16 net64 VGND VGND VPWR VPWR _070_ sky130_fd_sc_hd__mux2_1
XFILLER_13_141 VGND VGND VPWR VPWR sky130_fd_sc_hd__decap_4
X_297_ _145_ _147_ net81 VGND VGND VPWR VPWR net40 sky130_fd_sc_hd__o21a_1
X_366_ reg_array\[4\]\[5\] reg_array\[5\]\[5\] reg_array\[6\]\[5\] reg_array\[7\]\[5\]
+ net89 net88 VGND VGND VPWR VPWR _203_ sky130_fd_sc_hd__mux4_1
XFILLER_9_167 VGND VGND VPWR VPWR sky130_fd_sc_hd__fill_1
XTAP_TAPCELL_ROW_38_239 VGND VPWR sky130_fd_sc_hd__tapvpwrvgnd_1
XFILLER_3_97 VGND VGND VPWR VPWR sky130_fd_sc_hd__fill_1
XFILLER_6_137 VGND VGND VPWR VPWR sky130_fd_sc_hd__decap_3
XFILLER_33_225 VGND VGND VPWR VPWR sky130_fd_sc_hd__decap_4
X_349_ net86 _187_ _189_ net73 VGND VGND VPWR VPWR _190_ sky130_fd_sc_hd__a22o_1
X_418_ reg_array\[2\]\[15\] reg_array\[3\]\[15\] net90 VGND VGND VPWR VPWR _245_ sky130_fd_sc_hd__mux2_1
XTAP_TAPCELL_ROW_34_220 VGND VPWR sky130_fd_sc_hd__tapvpwrvgnd_1
XFILLER_3_107 VGND VGND VPWR VPWR sky130_fd_sc_hd__decap_4
XFILLER_2_184 VGND VGND VPWR VPWR sky130_fd_sc_hd__decap_3
XPHY_EDGE_ROW_4_Left_43 VGND VGND VPWR VPWR sky130_fd_sc_hd__decap_3
XFILLER_12_206 VGND VGND VPWR VPWR sky130_fd_sc_hd__decap_3
XPHY_EDGE_ROW_30_Left_69 VGND VGND VPWR VPWR sky130_fd_sc_hd__decap_3
XFILLER_38_169 VPWR VGND VPWR VGND sky130_ef_sc_hd__decap_12
XFILLER_38_147 VGND VGND VPWR VPWR sky130_fd_sc_hd__decap_3
XFILLER_30_29 VGND VGND VPWR VPWR sky130_fd_sc_hd__decap_4
XFILLER_29_169 VGND VGND VPWR VPWR sky130_fd_sc_hd__fill_1
XFILLER_29_125 VGND VGND VPWR VPWR sky130_fd_sc_hd__fill_2
XFILLER_20_62 VGND VGND VPWR VPWR sky130_fd_sc_hd__decap_8
XFILLER_4_224 VGND VGND VPWR VPWR sky130_fd_sc_hd__decap_4
X_597_ clknet_3_2__leaf_clk _049_ VGND VGND VPWR VPWR reg_array\[1\]\[9\] sky130_fd_sc_hd__dfxtp_1
Xhold60 reg_array\[7\]\[13\] VGND VGND VPWR VPWR net160 sky130_fd_sc_hd__dlygate4sd3_1
Xhold82 reg_array\[3\]\[11\] VGND VGND VPWR VPWR net182 sky130_fd_sc_hd__dlygate4sd3_1
Xhold71 reg_array\[2\]\[10\] VGND VGND VPWR VPWR net171 sky130_fd_sc_hd__dlygate4sd3_1
XFILLER_6_97 VGND VGND VPWR VPWR sky130_fd_sc_hd__decap_3
Xhold93 reg_array\[5\]\[0\] VGND VGND VPWR VPWR net193 sky130_fd_sc_hd__dlygate4sd3_1
X_520_ net117 net15 net62 VGND VGND VPWR VPWR _085_ sky130_fd_sc_hd__mux2_1
XFILLER_26_106 VGND VGND VPWR VPWR sky130_fd_sc_hd__decap_4
XFILLER_1_205 VPWR VGND VPWR VGND sky130_ef_sc_hd__decap_12
X_382_ reg_array\[1\]\[8\] net78 VGND VGND VPWR VPWR _216_ sky130_fd_sc_hd__and2_1
XPHY_EDGE_ROW_33_Left_72 VGND VGND VPWR VPWR sky130_fd_sc_hd__decap_3
X_451_ net198 net14 net70 VGND VGND VPWR VPWR _020_ sky130_fd_sc_hd__mux2_1
X_649_ clknet_3_3__leaf_clk _101_ VGND VGND VPWR VPWR reg_array\[7\]\[13\] sky130_fd_sc_hd__dfxtp_1
Xoutput50 net50 VGND VGND VPWR VPWR RD2[1] sky130_fd_sc_hd__buf_2
XTAP_TAPCELL_ROW_18_156 VGND VPWR sky130_fd_sc_hd__tapvpwrvgnd_1
XFILLER_16_150 VGND VGND VPWR VPWR sky130_fd_sc_hd__fill_1
XFILLER_16_172 VGND VGND VPWR VPWR sky130_fd_sc_hd__decap_6
X_434_ net200 net14 net72 VGND VGND VPWR VPWR _004_ sky130_fd_sc_hd__mux2_1
XFILLER_26_61 VGND VGND VPWR VPWR sky130_fd_sc_hd__decap_3
X_503_ net199 net15 net63 VGND VGND VPWR VPWR _069_ sky130_fd_sc_hd__mux2_1
X_365_ _200_ _202_ net75 VGND VGND VPWR VPWR net53 sky130_fd_sc_hd__o21a_1
X_296_ net93 _144_ _146_ net79 VGND VGND VPWR VPWR _147_ sky130_fd_sc_hd__a22o_1
XFILLER_9_113 VGND VGND VPWR VPWR sky130_fd_sc_hd__fill_1
XFILLER_22_19 VGND VGND VPWR VPWR sky130_fd_sc_hd__decap_8
XFILLER_27_212 VGND VGND VPWR VPWR sky130_fd_sc_hd__decap_3
XTAP_TAPCELL_ROW_20_162 VGND VPWR sky130_fd_sc_hd__tapvpwrvgnd_1
XFILLER_12_85 VGND VGND VPWR VPWR sky130_fd_sc_hd__fill_2
XFILLER_12_63 VGND VGND VPWR VPWR sky130_fd_sc_hd__fill_1
XFILLER_10_167 VGND VGND VPWR VPWR sky130_fd_sc_hd__decap_8
XPHY_EDGE_ROW_25_Right_25 VGND VGND VPWR VPWR sky130_fd_sc_hd__decap_3
X_348_ reg_array\[2\]\[1\] reg_array\[3\]\[1\] net91 VGND VGND VPWR VPWR _189_ sky130_fd_sc_hd__mux2_1
X_417_ reg_array\[1\]\[15\] net78 VGND VGND VPWR VPWR _244_ sky130_fd_sc_hd__and2_1
XFILLER_18_212 VGND VGND VPWR VPWR sky130_fd_sc_hd__fill_2
XPHY_EDGE_ROW_16_Right_16 VGND VGND VPWR VPWR sky130_fd_sc_hd__decap_3
X_279_ reg_array\[1\]\[4\] net83 VGND VGND VPWR VPWR _133_ sky130_fd_sc_hd__and2_1
XFILLER_5_160 VGND VGND VPWR VPWR sky130_fd_sc_hd__decap_8
XPHY_EDGE_ROW_34_Right_34 VGND VGND VPWR VPWR sky130_fd_sc_hd__decap_3
XTAP_TAPCELL_ROW_34_221 VGND VPWR sky130_fd_sc_hd__tapvpwrvgnd_1
XFILLER_28_29 VGND VGND VPWR VPWR sky130_fd_sc_hd__decap_4
XFILLER_0_55 VGND VGND VPWR VPWR sky130_fd_sc_hd__fill_1
Xclkbuf_3_0__f_clk clknet_0_clk VGND VGND VPWR VPWR clknet_3_0__leaf_clk sky130_fd_sc_hd__clkbuf_16
XFILLER_37_181 VPWR VGND VPWR VGND sky130_ef_sc_hd__decap_12
XFILLER_29_148 VPWR VGND VPWR VGND sky130_ef_sc_hd__decap_12
XPHY_EDGE_ROW_2_Right_2 VGND VGND VPWR VPWR sky130_fd_sc_hd__decap_3
X_596_ clknet_3_7__leaf_clk _048_ VGND VGND VPWR VPWR reg_array\[1\]\[8\] sky130_fd_sc_hd__dfxtp_1
XFILLER_29_72 VGND VGND VPWR VPWR sky130_fd_sc_hd__fill_1
XFILLER_28_192 VGND VGND VPWR VPWR sky130_fd_sc_hd__decap_4
Xhold72 reg_array\[2\]\[1\] VGND VGND VPWR VPWR net172 sky130_fd_sc_hd__dlygate4sd3_1
Xhold50 reg_array\[5\]\[12\] VGND VGND VPWR VPWR net150 sky130_fd_sc_hd__dlygate4sd3_1
Xhold61 reg_array\[2\]\[15\] VGND VGND VPWR VPWR net161 sky130_fd_sc_hd__dlygate4sd3_1
Xhold83 reg_array\[5\]\[3\] VGND VGND VPWR VPWR net183 sky130_fd_sc_hd__dlygate4sd3_1
Xhold94 reg_array\[4\]\[4\] VGND VGND VPWR VPWR net194 sky130_fd_sc_hd__dlygate4sd3_1
XFILLER_1_217 VGND VGND VPWR VPWR sky130_fd_sc_hd__decap_6
X_381_ reg_array\[4\]\[8\] reg_array\[5\]\[8\] reg_array\[6\]\[8\] reg_array\[7\]\[8\]
+ net92 net87 VGND VGND VPWR VPWR _215_ sky130_fd_sc_hd__mux4_1
XFILLER_31_84 VGND VGND VPWR VPWR sky130_fd_sc_hd__fill_2
X_450_ net182 net13 net70 VGND VGND VPWR VPWR _019_ sky130_fd_sc_hd__mux2_1
Xoutput51 net51 VGND VGND VPWR VPWR RD2[2] sky130_fd_sc_hd__buf_2
Xoutput40 net40 VGND VGND VPWR VPWR RD1[7] sky130_fd_sc_hd__buf_2
XFILLER_36_29 VPWR VGND VPWR VGND sky130_ef_sc_hd__decap_12
X_648_ clknet_3_6__leaf_clk _100_ VGND VGND VPWR VPWR reg_array\[7\]\[12\] sky130_fd_sc_hd__dfxtp_1
XTAP_TAPCELL_ROW_18_157 VGND VPWR sky130_fd_sc_hd__tapvpwrvgnd_1
XFILLER_16_195 VGND VGND VPWR VPWR sky130_fd_sc_hd__fill_1
X_579_ clknet_3_1__leaf_clk _031_ VGND VGND VPWR VPWR reg_array\[2\]\[7\] sky130_fd_sc_hd__dfxtp_1
X_502_ net148 net14 net64 VGND VGND VPWR VPWR _068_ sky130_fd_sc_hd__mux2_1
X_433_ net155 net13 net72 VGND VGND VPWR VPWR _003_ sky130_fd_sc_hd__mux2_1
XFILLER_13_154 VGND VGND VPWR VPWR sky130_fd_sc_hd__decap_3
X_295_ reg_array\[2\]\[7\] reg_array\[3\]\[7\] net97 VGND VGND VPWR VPWR _146_ sky130_fd_sc_hd__mux2_1
X_364_ net86 _199_ _201_ net74 VGND VGND VPWR VPWR _202_ sky130_fd_sc_hd__a22o_1
XFILLER_9_169 VGND VGND VPWR VPWR sky130_fd_sc_hd__decap_6
XTAP_TAPCELL_ROW_37_230 VGND VPWR sky130_fd_sc_hd__tapvpwrvgnd_1
XTAP_TAPCELL_ROW_6_106 VGND VPWR sky130_fd_sc_hd__tapvpwrvgnd_1
XFILLER_6_106 VGND VGND VPWR VPWR sky130_fd_sc_hd__decap_6
XFILLER_37_61 VGND VGND VPWR VPWR sky130_fd_sc_hd__fill_1
X_347_ reg_array\[1\]\[1\] net77 VGND VGND VPWR VPWR _188_ sky130_fd_sc_hd__and2_1
X_416_ reg_array\[4\]\[15\] reg_array\[5\]\[15\] reg_array\[6\]\[15\] reg_array\[7\]\[15\]
+ net90 net88 VGND VGND VPWR VPWR _243_ sky130_fd_sc_hd__mux4_1
XTAP_TAPCELL_ROW_20_163 VGND VPWR sky130_fd_sc_hd__tapvpwrvgnd_1
XFILLER_5_3 VPWR VGND VPWR VGND sky130_ef_sc_hd__decap_12
X_278_ reg_array\[4\]\[4\] reg_array\[5\]\[4\] reg_array\[6\]\[4\] reg_array\[7\]\[4\]
+ net99 net95 VGND VGND VPWR VPWR _132_ sky130_fd_sc_hd__mux4_1
XFILLER_38_3 VPWR VGND VPWR VGND sky130_ef_sc_hd__decap_12
XFILLER_2_164 VPWR VGND VPWR VGND sky130_ef_sc_hd__decap_12
XFILLER_2_197 VPWR VGND VPWR VGND sky130_ef_sc_hd__decap_12
XFILLER_0_45 VGND VGND VPWR VPWR sky130_fd_sc_hd__fill_1
XFILLER_0_23 VGND VGND VPWR VPWR sky130_fd_sc_hd__fill_1
XFILLER_18_41 VGND VGND VPWR VPWR sky130_fd_sc_hd__decap_4
XFILLER_37_193 VPWR VGND VPWR VGND sky130_ef_sc_hd__decap_12
XFILLER_35_119 VPWR VGND VPWR VGND sky130_ef_sc_hd__decap_12
Xhold40 reg_array\[2\]\[9\] VGND VGND VPWR VPWR net140 sky130_fd_sc_hd__dlygate4sd3_1
XFILLER_29_62 VGND VGND VPWR VPWR sky130_fd_sc_hd__fill_1
Xhold95 reg_array\[4\]\[13\] VGND VGND VPWR VPWR net195 sky130_fd_sc_hd__dlygate4sd3_1
Xhold51 reg_array\[1\]\[14\] VGND VGND VPWR VPWR net151 sky130_fd_sc_hd__dlygate4sd3_1
Xhold73 reg_array\[1\]\[10\] VGND VGND VPWR VPWR net173 sky130_fd_sc_hd__dlygate4sd3_1
X_595_ clknet_3_1__leaf_clk _047_ VGND VGND VPWR VPWR reg_array\[1\]\[7\] sky130_fd_sc_hd__dfxtp_1
Xhold84 reg_array\[3\]\[0\] VGND VGND VPWR VPWR net184 sky130_fd_sc_hd__dlygate4sd3_1
Xhold62 reg_array\[2\]\[0\] VGND VGND VPWR VPWR net162 sky130_fd_sc_hd__dlygate4sd3_1
XFILLER_34_185 VGND VGND VPWR VPWR sky130_fd_sc_hd__decap_8
XFILLER_34_141 VGND VGND VPWR VPWR sky130_fd_sc_hd__decap_4
XFILLER_34_130 VGND VGND VPWR VPWR sky130_fd_sc_hd__fill_1
XFILLER_6_66 VGND VGND VPWR VPWR sky130_fd_sc_hd__decap_3
Xoutput30 net30 VGND VGND VPWR VPWR RD1[12] sky130_fd_sc_hd__buf_2
Xoutput41 net41 VGND VGND VPWR VPWR RD1[8] sky130_fd_sc_hd__buf_2
Xoutput52 net52 VGND VGND VPWR VPWR RD2[3] sky130_fd_sc_hd__buf_2
X_380_ _212_ _214_ net75 VGND VGND VPWR VPWR net56 sky130_fd_sc_hd__o21a_1
XFILLER_31_111 VGND VGND VPWR VPWR sky130_fd_sc_hd__fill_1
X_578_ clknet_3_2__leaf_clk _030_ VGND VGND VPWR VPWR reg_array\[2\]\[6\] sky130_fd_sc_hd__dfxtp_1
X_647_ clknet_3_6__leaf_clk _099_ VGND VGND VPWR VPWR reg_array\[7\]\[11\] sky130_fd_sc_hd__dfxtp_1
.ends
