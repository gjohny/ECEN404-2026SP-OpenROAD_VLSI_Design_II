* NGSPICE file created from ALU.ext - technology: sky130A

* Black-box entry subcircuit for sky130_fd_sc_hd__tapvpwrvgnd_1 abstract view
.subckt sky130_fd_sc_hd__tapvpwrvgnd_1 VGND VPWR
.ends

* Black-box entry subcircuit for sky130_fd_sc_hd__decap_6 abstract view
.subckt sky130_fd_sc_hd__decap_6 VGND VNB VPB VPWR
.ends

* Black-box entry subcircuit for sky130_fd_sc_hd__decap_8 abstract view
.subckt sky130_fd_sc_hd__decap_8 VGND VNB VPB VPWR
.ends

* Black-box entry subcircuit for sky130_ef_sc_hd__decap_12 abstract view
.subckt sky130_ef_sc_hd__decap_12 VPWR VGND VPB VNB
.ends

* Black-box entry subcircuit for sky130_fd_sc_hd__mux4_1 abstract view
.subckt sky130_fd_sc_hd__mux4_1 A0 A1 A2 A3 S0 S1 VGND VNB VPB VPWR X
.ends

* Black-box entry subcircuit for sky130_fd_sc_hd__a221o_1 abstract view
.subckt sky130_fd_sc_hd__a221o_1 A1 A2 B1 B2 C1 VGND VNB VPB VPWR X
.ends

* Black-box entry subcircuit for sky130_fd_sc_hd__buf_2 abstract view
.subckt sky130_fd_sc_hd__buf_2 A VGND VNB VPB VPWR X
.ends

* Black-box entry subcircuit for sky130_fd_sc_hd__decap_3 abstract view
.subckt sky130_fd_sc_hd__decap_3 VGND VNB VPB VPWR
.ends

* Black-box entry subcircuit for sky130_fd_sc_hd__decap_4 abstract view
.subckt sky130_fd_sc_hd__decap_4 VGND VNB VPB VPWR
.ends

* Black-box entry subcircuit for sky130_fd_sc_hd__a211o_1 abstract view
.subckt sky130_fd_sc_hd__a211o_1 A1 A2 B1 C1 VGND VNB VPB VPWR X
.ends

* Black-box entry subcircuit for sky130_fd_sc_hd__fill_2 abstract view
.subckt sky130_fd_sc_hd__fill_2 VGND VNB VPB VPWR
.ends

* Black-box entry subcircuit for sky130_fd_sc_hd__fill_1 abstract view
.subckt sky130_fd_sc_hd__fill_1 VGND VNB VPB VPWR
.ends

* Black-box entry subcircuit for sky130_fd_sc_hd__nand2_1 abstract view
.subckt sky130_fd_sc_hd__nand2_1 A B VGND VNB VPB VPWR Y
.ends

* Black-box entry subcircuit for sky130_fd_sc_hd__o41a_1 abstract view
.subckt sky130_fd_sc_hd__o41a_1 A1 A2 A3 A4 B1 VGND VNB VPB VPWR X
.ends

* Black-box entry subcircuit for sky130_fd_sc_hd__a21oi_1 abstract view
.subckt sky130_fd_sc_hd__a21oi_1 A1 A2 B1 VGND VNB VPB VPWR Y
.ends

* Black-box entry subcircuit for sky130_fd_sc_hd__o22a_1 abstract view
.subckt sky130_fd_sc_hd__o22a_1 A1 A2 B1 B2 VGND VNB VPB VPWR X
.ends

* Black-box entry subcircuit for sky130_fd_sc_hd__o311a_1 abstract view
.subckt sky130_fd_sc_hd__o311a_1 A1 A2 A3 B1 C1 VGND VNB VPB VPWR X
.ends

* Black-box entry subcircuit for sky130_fd_sc_hd__a22o_1 abstract view
.subckt sky130_fd_sc_hd__a22o_1 A1 A2 B1 B2 VGND VNB VPB VPWR X
.ends

* Black-box entry subcircuit for sky130_fd_sc_hd__and2_1 abstract view
.subckt sky130_fd_sc_hd__and2_1 A B VGND VNB VPB VPWR X
.ends

* Black-box entry subcircuit for sky130_fd_sc_hd__o31ai_1 abstract view
.subckt sky130_fd_sc_hd__o31ai_1 A1 A2 A3 B1 VGND VNB VPB VPWR Y
.ends

* Black-box entry subcircuit for sky130_fd_sc_hd__mux2_1 abstract view
.subckt sky130_fd_sc_hd__mux2_1 A0 A1 S VGND VNB VPB VPWR X
.ends

* Black-box entry subcircuit for sky130_fd_sc_hd__a21o_1 abstract view
.subckt sky130_fd_sc_hd__a21o_1 A1 A2 B1 VGND VNB VPB VPWR X
.ends

* Black-box entry subcircuit for sky130_fd_sc_hd__and3_1 abstract view
.subckt sky130_fd_sc_hd__and3_1 A B C VGND VNB VPB VPWR X
.ends

* Black-box entry subcircuit for sky130_fd_sc_hd__o211ai_1 abstract view
.subckt sky130_fd_sc_hd__o211ai_1 A1 A2 B1 C1 VGND VNB VPB VPWR Y
.ends

* Black-box entry subcircuit for sky130_fd_sc_hd__a311o_1 abstract view
.subckt sky130_fd_sc_hd__a311o_1 A1 A2 A3 B1 C1 VGND VNB VPB VPWR X
.ends

* Black-box entry subcircuit for sky130_fd_sc_hd__nor2_4 abstract view
.subckt sky130_fd_sc_hd__nor2_4 A B VGND VNB VPB VPWR Y
.ends

* Black-box entry subcircuit for sky130_fd_sc_hd__or2_1 abstract view
.subckt sky130_fd_sc_hd__or2_1 A B VGND VNB VPB VPWR X
.ends

* Black-box entry subcircuit for sky130_fd_sc_hd__o21ai_1 abstract view
.subckt sky130_fd_sc_hd__o21ai_1 A1 A2 B1 VGND VNB VPB VPWR Y
.ends

* Black-box entry subcircuit for sky130_fd_sc_hd__o21a_1 abstract view
.subckt sky130_fd_sc_hd__o21a_1 A1 A2 B1 VGND VNB VPB VPWR X
.ends

* Black-box entry subcircuit for sky130_fd_sc_hd__or4b_4 abstract view
.subckt sky130_fd_sc_hd__or4b_4 A B C D_N VGND VNB VPB VPWR X
.ends

* Black-box entry subcircuit for sky130_fd_sc_hd__or3_1 abstract view
.subckt sky130_fd_sc_hd__or3_1 A B C VGND VNB VPB VPWR X
.ends

* Black-box entry subcircuit for sky130_fd_sc_hd__xnor2_1 abstract view
.subckt sky130_fd_sc_hd__xnor2_1 A B VGND VNB VPB VPWR Y
.ends

* Black-box entry subcircuit for sky130_fd_sc_hd__nor4b_2 abstract view
.subckt sky130_fd_sc_hd__nor4b_2 A B C D_N VGND VNB VPB VPWR Y
.ends

* Black-box entry subcircuit for sky130_fd_sc_hd__buf_1 abstract view
.subckt sky130_fd_sc_hd__buf_1 A VGND VNB VPB VPWR X
.ends

* Black-box entry subcircuit for sky130_fd_sc_hd__clkbuf_2 abstract view
.subckt sky130_fd_sc_hd__clkbuf_2 A VGND VNB VPB VPWR X
.ends

* Black-box entry subcircuit for sky130_fd_sc_hd__and3_2 abstract view
.subckt sky130_fd_sc_hd__and3_2 A B C VGND VNB VPB VPWR X
.ends

* Black-box entry subcircuit for sky130_fd_sc_hd__nor2_1 abstract view
.subckt sky130_fd_sc_hd__nor2_1 A B VGND VNB VPB VPWR Y
.ends

* Black-box entry subcircuit for sky130_fd_sc_hd__a31o_1 abstract view
.subckt sky130_fd_sc_hd__a31o_1 A1 A2 A3 B1 VGND VNB VPB VPWR X
.ends

* Black-box entry subcircuit for sky130_fd_sc_hd__nor3_1 abstract view
.subckt sky130_fd_sc_hd__nor3_1 A B C VGND VNB VPB VPWR Y
.ends

* Black-box entry subcircuit for sky130_fd_sc_hd__o211ai_2 abstract view
.subckt sky130_fd_sc_hd__o211ai_2 A1 A2 B1 C1 VGND VNB VPB VPWR Y
.ends

* Black-box entry subcircuit for sky130_fd_sc_hd__clkbuf_4 abstract view
.subckt sky130_fd_sc_hd__clkbuf_4 A VGND VNB VPB VPWR X
.ends

* Black-box entry subcircuit for sky130_fd_sc_hd__xor2_1 abstract view
.subckt sky130_fd_sc_hd__xor2_1 A B VGND VNB VPB VPWR X
.ends

* Black-box entry subcircuit for sky130_fd_sc_hd__and3b_1 abstract view
.subckt sky130_fd_sc_hd__and3b_1 A_N B C VGND VNB VPB VPWR X
.ends

* Black-box entry subcircuit for sky130_fd_sc_hd__o31a_1 abstract view
.subckt sky130_fd_sc_hd__o31a_1 A1 A2 A3 B1 VGND VNB VPB VPWR X
.ends

* Black-box entry subcircuit for sky130_fd_sc_hd__and2b_1 abstract view
.subckt sky130_fd_sc_hd__and2b_1 A_N B VGND VNB VPB VPWR X
.ends

* Black-box entry subcircuit for sky130_fd_sc_hd__inv_2 abstract view
.subckt sky130_fd_sc_hd__inv_2 A VGND VNB VPB VPWR Y
.ends

* Black-box entry subcircuit for sky130_fd_sc_hd__and4b_1 abstract view
.subckt sky130_fd_sc_hd__and4b_1 A_N B C D VGND VNB VPB VPWR X
.ends

* Black-box entry subcircuit for sky130_fd_sc_hd__o211a_1 abstract view
.subckt sky130_fd_sc_hd__o211a_1 A1 A2 B1 C1 VGND VNB VPB VPWR X
.ends

* Black-box entry subcircuit for sky130_fd_sc_hd__or4_2 abstract view
.subckt sky130_fd_sc_hd__or4_2 A B C D VGND VNB VPB VPWR X
.ends

* Black-box entry subcircuit for sky130_fd_sc_hd__or3b_1 abstract view
.subckt sky130_fd_sc_hd__or3b_1 A B C_N VGND VNB VPB VPWR X
.ends

* Black-box entry subcircuit for sky130_fd_sc_hd__nor4b_1 abstract view
.subckt sky130_fd_sc_hd__nor4b_1 A B C D_N VGND VNB VPB VPWR Y
.ends

* Black-box entry subcircuit for sky130_fd_sc_hd__nand2b_1 abstract view
.subckt sky130_fd_sc_hd__nand2b_1 A_N B VGND VNB VPB VPWR Y
.ends

* Black-box entry subcircuit for sky130_fd_sc_hd__xor2_2 abstract view
.subckt sky130_fd_sc_hd__xor2_2 A B VGND VNB VPB VPWR X
.ends

* Black-box entry subcircuit for sky130_fd_sc_hd__and4bb_1 abstract view
.subckt sky130_fd_sc_hd__and4bb_1 A_N B_N C D VGND VNB VPB VPWR X
.ends

* Black-box entry subcircuit for sky130_fd_sc_hd__nand3b_1 abstract view
.subckt sky130_fd_sc_hd__nand3b_1 A_N B C VGND VNB VPB VPWR Y
.ends

* Black-box entry subcircuit for sky130_fd_sc_hd__or4_1 abstract view
.subckt sky130_fd_sc_hd__or4_1 A B C D VGND VNB VPB VPWR X
.ends

* Black-box entry subcircuit for sky130_fd_sc_hd__nand3_1 abstract view
.subckt sky130_fd_sc_hd__nand3_1 A B C VGND VNB VPB VPWR Y
.ends

* Black-box entry subcircuit for sky130_fd_sc_hd__or4b_1 abstract view
.subckt sky130_fd_sc_hd__or4b_1 A B C D_N VGND VNB VPB VPWR X
.ends

* Black-box entry subcircuit for sky130_fd_sc_hd__dlymetal6s2s_1 abstract view
.subckt sky130_fd_sc_hd__dlymetal6s2s_1 A VGND VNB VPB VPWR X
.ends

* Black-box entry subcircuit for sky130_fd_sc_hd__clkbuf_1 abstract view
.subckt sky130_fd_sc_hd__clkbuf_1 A VGND VNB VPB VPWR X
.ends

* Black-box entry subcircuit for sky130_fd_sc_hd__and2_2 abstract view
.subckt sky130_fd_sc_hd__and2_2 A B VGND VNB VPB VPWR X
.ends

* Black-box entry subcircuit for sky130_fd_sc_hd__a21boi_1 abstract view
.subckt sky130_fd_sc_hd__a21boi_1 A1 A2 B1_N VGND VNB VPB VPWR Y
.ends

* Black-box entry subcircuit for sky130_fd_sc_hd__a21bo_1 abstract view
.subckt sky130_fd_sc_hd__a21bo_1 A1 A2 B1_N VGND VNB VPB VPWR X
.ends

* Black-box entry subcircuit for sky130_fd_sc_hd__or2_2 abstract view
.subckt sky130_fd_sc_hd__or2_2 A B VGND VNB VPB VPWR X
.ends

* Black-box entry subcircuit for sky130_fd_sc_hd__nor2_2 abstract view
.subckt sky130_fd_sc_hd__nor2_2 A B VGND VNB VPB VPWR Y
.ends

* Black-box entry subcircuit for sky130_fd_sc_hd__or3_2 abstract view
.subckt sky130_fd_sc_hd__or3_2 A B C VGND VNB VPB VPWR X
.ends

* Black-box entry subcircuit for sky130_fd_sc_hd__nand2_2 abstract view
.subckt sky130_fd_sc_hd__nand2_2 A B VGND VNB VPB VPWR Y
.ends

* Black-box entry subcircuit for sky130_fd_sc_hd__a2bb2o_1 abstract view
.subckt sky130_fd_sc_hd__a2bb2o_1 A1_N A2_N B1 B2 VGND VNB VPB VPWR X
.ends

* Black-box entry subcircuit for sky130_fd_sc_hd__and4_1 abstract view
.subckt sky130_fd_sc_hd__and4_1 A B C D VGND VNB VPB VPWR X
.ends

* Black-box entry subcircuit for sky130_fd_sc_hd__a211oi_1 abstract view
.subckt sky130_fd_sc_hd__a211oi_1 A1 A2 B1 C1 VGND VNB VPB VPWR Y
.ends

* Black-box entry subcircuit for sky130_fd_sc_hd__or3b_4 abstract view
.subckt sky130_fd_sc_hd__or3b_4 A B C_N VGND VNB VPB VPWR X
.ends

* Black-box entry subcircuit for sky130_fd_sc_hd__o21ba_1 abstract view
.subckt sky130_fd_sc_hd__o21ba_1 A1 A2 B1_N VGND VNB VPB VPWR X
.ends

* Black-box entry subcircuit for sky130_fd_sc_hd__nor3b_1 abstract view
.subckt sky130_fd_sc_hd__nor3b_1 A B C_N VGND VNB VPB VPWR Y
.ends

* Black-box entry subcircuit for sky130_fd_sc_hd__a32o_1 abstract view
.subckt sky130_fd_sc_hd__a32o_1 A1 A2 A3 B1 B2 VGND VNB VPB VPWR X
.ends

* Black-box entry subcircuit for sky130_fd_sc_hd__a211oi_2 abstract view
.subckt sky130_fd_sc_hd__a211oi_2 A1 A2 B1 C1 VGND VNB VPB VPWR Y
.ends

* Black-box entry subcircuit for sky130_fd_sc_hd__a31oi_1 abstract view
.subckt sky130_fd_sc_hd__a31oi_1 A1 A2 A3 B1 VGND VNB VPB VPWR Y
.ends

* Black-box entry subcircuit for sky130_fd_sc_hd__nand3b_2 abstract view
.subckt sky130_fd_sc_hd__nand3b_2 A_N B C VGND VNB VPB VPWR Y
.ends

* Black-box entry subcircuit for sky130_fd_sc_hd__and3b_2 abstract view
.subckt sky130_fd_sc_hd__and3b_2 A_N B C VGND VNB VPB VPWR X
.ends

* Black-box entry subcircuit for sky130_fd_sc_hd__or4_4 abstract view
.subckt sky130_fd_sc_hd__or4_4 A B C D VGND VNB VPB VPWR X
.ends

* Black-box entry subcircuit for sky130_fd_sc_hd__or3_4 abstract view
.subckt sky130_fd_sc_hd__or3_4 A B C VGND VNB VPB VPWR X
.ends

* Black-box entry subcircuit for sky130_fd_sc_hd__o221a_1 abstract view
.subckt sky130_fd_sc_hd__o221a_1 A1 A2 B1 B2 C1 VGND VNB VPB VPWR X
.ends

* Black-box entry subcircuit for sky130_fd_sc_hd__and2b_2 abstract view
.subckt sky130_fd_sc_hd__and2b_2 A_N B VGND VNB VPB VPWR X
.ends

.subckt ALU ALU_control[0] ALU_control[1] ALU_control[2] ALU_control[3] ALU_result[0]
+ ALU_result[10] ALU_result[11] ALU_result[12] ALU_result[13] ALU_result[14] ALU_result[15]
+ ALU_result[1] ALU_result[2] ALU_result[3] ALU_result[4] ALU_result[5] ALU_result[6]
+ ALU_result[7] ALU_result[8] ALU_result[9] SrcA[0] SrcA[10] SrcA[11] SrcA[12] SrcA[13]
+ SrcA[14] SrcA[15] SrcA[1] SrcA[2] SrcA[3] SrcA[4] SrcA[5] SrcA[6] SrcA[7] SrcA[8]
+ SrcA[9] SrcB[0] SrcB[10] SrcB[11] SrcB[12] SrcB[13] SrcB[14] SrcB[15] SrcB[1] SrcB[2]
+ SrcB[3] SrcB[4] SrcB[5] SrcB[6] SrcB[7] SrcB[8] SrcB[9] VGND VPWR zero
XTAP_TAPCELL_ROW_24_139 VGND VPWR sky130_fd_sc_hd__tapvpwrvgnd_1
XFILLER_22_133 VGND VGND VPWR VPWR sky130_fd_sc_hd__decap_6
XFILLER_22_111 VGND VGND VPWR VPWR sky130_fd_sc_hd__decap_6
XFILLER_7_7 VGND VGND VPWR VPWR sky130_fd_sc_hd__decap_8
XFILLER_26_85 VPWR VGND VPWR VGND sky130_ef_sc_hd__decap_12
X_432_ net87 net66 net64 net62 net84 net78 VGND VGND VPWR VPWR _010_ sky130_fd_sc_hd__mux4_1
XFILLER_13_133 VGND VGND VPWR VPWR sky130_fd_sc_hd__decap_6
X_501_ net67 _064_ _076_ _339_ _073_ VGND VGND VPWR VPWR _077_ sky130_fd_sc_hd__a221o_1
Xfanout105 net106 VGND VGND VPWR VPWR net105 sky130_fd_sc_hd__buf_2
XFILLER_12_76 VGND VGND VPWR VPWR sky130_fd_sc_hd__decap_3
XFILLER_12_10 VGND VGND VPWR VPWR sky130_fd_sc_hd__decap_3
XFILLER_10_125 VGND VGND VPWR VPWR sky130_fd_sc_hd__decap_4
X_415_ net5 _369_ _358_ _353_ VGND VGND VPWR VPWR net37 sky130_fd_sc_hd__a211o_1
XFILLER_5_151 VGND VGND VPWR VPWR sky130_fd_sc_hd__fill_2
XFILLER_0_79 VGND VGND VPWR VPWR sky130_fd_sc_hd__fill_1
XFILLER_0_57 VGND VGND VPWR VPWR sky130_fd_sc_hd__fill_2
XFILLER_9_55 VGND VGND VPWR VPWR sky130_fd_sc_hd__fill_1
X_680_ _171_ _174_ _213_ _246_ VGND VGND VPWR VPWR _247_ sky130_fd_sc_hd__a211o_1
XFILLER_29_117 VGND VGND VPWR VPWR sky130_fd_sc_hd__fill_1
X_732_ _293_ _295_ VGND VGND VPWR VPWR _297_ sky130_fd_sc_hd__nand2_1
X_663_ net35 net36 net22 _176_ net56 VGND VGND VPWR VPWR _231_ sky130_fd_sc_hd__o41a_1
X_594_ _363_ _165_ _163_ VGND VGND VPWR VPWR _166_ sky130_fd_sc_hd__a21oi_1
XFILLER_26_109 VGND VGND VPWR VPWR sky130_fd_sc_hd__fill_1
XPHY_EDGE_ROW_16_Left_48 VGND VGND VPWR VPWR sky130_fd_sc_hd__decap_3
XFILLER_13_3 VPWR VGND VPWR VGND sky130_ef_sc_hd__decap_12
XFILLER_6_56 VGND VGND VPWR VPWR sky130_fd_sc_hd__fill_1
XFILLER_31_53 VGND VGND VPWR VPWR sky130_fd_sc_hd__decap_3
XTAP_TAPCELL_ROW_27_148 VGND VPWR sky130_fd_sc_hd__tapvpwrvgnd_1
XFILLER_31_189 VGND VGND VPWR VPWR sky130_fd_sc_hd__fill_1
Xoutput53 net53 VGND VGND VPWR VPWR zero sky130_fd_sc_hd__buf_2
Xoutput42 net42 VGND VGND VPWR VPWR ALU_result[14] sky130_fd_sc_hd__buf_2
X_646_ _334_ _178_ _195_ _335_ VGND VGND VPWR VPWR _215_ sky130_fd_sc_hd__o22a_1
X_715_ _349_ _204_ _280_ _346_ VGND VGND VPWR VPWR _281_ sky130_fd_sc_hd__o22a_1
X_577_ _367_ _148_ _149_ _144_ _147_ VGND VGND VPWR VPWR _150_ sky130_fd_sc_hd__o311a_1
XFILLER_22_189 VGND VGND VPWR VPWR sky130_fd_sc_hd__fill_1
XFILLER_26_97 VPWR VGND VPWR VGND sky130_ef_sc_hd__decap_12
XFILLER_26_75 VGND VGND VPWR VPWR sky130_fd_sc_hd__decap_8
XFILLER_13_189 VGND VGND VPWR VPWR sky130_fd_sc_hd__fill_1
X_500_ _348_ _074_ _075_ _345_ VGND VGND VPWR VPWR _076_ sky130_fd_sc_hd__a22o_1
X_431_ net67 _362_ _004_ _007_ _008_ VGND VGND VPWR VPWR _009_ sky130_fd_sc_hd__o311a_1
XFILLER_9_127 VGND VGND VPWR VPWR sky130_fd_sc_hd__decap_4
XFILLER_9_138 VGND VGND VPWR VPWR sky130_fd_sc_hd__decap_4
X_629_ _335_ _192_ VGND VGND VPWR VPWR _199_ sky130_fd_sc_hd__and2_1
Xfanout106 net1 VGND VGND VPWR VPWR net106 sky130_fd_sc_hd__buf_2
XPHY_EDGE_ROW_19_Left_51 VGND VGND VPWR VPWR sky130_fd_sc_hd__decap_3
XFILLER_12_44 VPWR VGND VPWR VGND sky130_ef_sc_hd__decap_12
XFILLER_10_137 VGND VGND VPWR VPWR sky130_fd_sc_hd__decap_3
XFILLER_5_130 VGND VGND VPWR VPWR sky130_fd_sc_hd__decap_3
X_414_ _363_ net59 _368_ net82 _366_ VGND VGND VPWR VPWR _369_ sky130_fd_sc_hd__a221o_1
XFILLER_23_43 VPWR VGND VPWR VGND sky130_ef_sc_hd__decap_12
XFILLER_23_10 VGND VGND VPWR VPWR sky130_fd_sc_hd__fill_1
XPHY_EDGE_ROW_21_Right_21 VGND VGND VPWR VPWR sky130_fd_sc_hd__decap_3
XPHY_EDGE_ROW_12_Right_12 VGND VGND VPWR VPWR sky130_fd_sc_hd__decap_3
XPHY_EDGE_ROW_4_Left_36 VGND VGND VPWR VPWR sky130_fd_sc_hd__decap_3
XPHY_EDGE_ROW_30_Right_30 VGND VGND VPWR VPWR sky130_fd_sc_hd__decap_3
XFILLER_23_98 VGND VGND VPWR VPWR sky130_fd_sc_hd__fill_2
XFILLER_0_69 VGND VGND VPWR VPWR sky130_fd_sc_hd__fill_1
XFILLER_2_133 VGND VGND VPWR VPWR sky130_fd_sc_hd__fill_1
XFILLER_2_155 VPWR VGND VPWR VGND sky130_ef_sc_hd__decap_12
XFILLER_15_7 VGND VGND VPWR VPWR sky130_fd_sc_hd__decap_3
X_731_ _256_ _294_ _293_ _274_ VGND VGND VPWR VPWR _296_ sky130_fd_sc_hd__a211o_1
XFILLER_29_31 VPWR VGND VPWR VGND sky130_ef_sc_hd__decap_12
X_662_ _371_ _217_ _218_ _230_ VGND VGND VPWR VPWR net38 sky130_fd_sc_hd__o31ai_1
XFILLER_20_77 VGND VGND VPWR VPWR sky130_fd_sc_hd__decap_6
XFILLER_1_90 VGND VGND VPWR VPWR sky130_fd_sc_hd__decap_4
X_593_ _164_ _065_ net74 VGND VGND VPWR VPWR _165_ sky130_fd_sc_hd__mux2_1
XTAP_TAPCELL_ROW_27_149 VGND VPWR sky130_fd_sc_hd__tapvpwrvgnd_1
XFILLER_25_165 VGND VGND VPWR VPWR sky130_fd_sc_hd__decap_3
XFILLER_25_121 VPWR VGND VPWR VGND sky130_ef_sc_hd__decap_12
XPHY_EDGE_ROW_6_Right_6 VGND VGND VPWR VPWR sky130_fd_sc_hd__decap_3
Xoutput43 net43 VGND VGND VPWR VPWR ALU_result[15] sky130_fd_sc_hd__buf_2
XFILLER_31_113 VGND VGND VPWR VPWR sky130_fd_sc_hd__fill_2
XFILLER_31_76 VGND VGND VPWR VPWR sky130_fd_sc_hd__decap_8
X_645_ _171_ _174_ _213_ VGND VGND VPWR VPWR _214_ sky130_fd_sc_hd__a21o_1
X_714_ net60 net62 net65 net66 net84 net78 VGND VGND VPWR VPWR _280_ sky130_fd_sc_hd__mux4_1
XFILLER_16_110 VGND VGND VPWR VPWR sky130_fd_sc_hd__fill_1
XFILLER_15_99 VGND VGND VPWR VPWR sky130_fd_sc_hd__decap_6
X_576_ net94 net92 _099_ VGND VGND VPWR VPWR _149_ sky130_fd_sc_hd__and3_1
XFILLER_22_157 VGND VGND VPWR VPWR sky130_fd_sc_hd__fill_1
XFILLER_26_10 VGND VGND VPWR VPWR sky130_fd_sc_hd__fill_2
XFILLER_13_157 VGND VGND VPWR VPWR sky130_fd_sc_hd__decap_8
XFILLER_13_113 VPWR VGND VPWR VGND sky130_ef_sc_hd__decap_12
XFILLER_13_102 VGND VGND VPWR VPWR sky130_fd_sc_hd__decap_3
X_430_ net100 net75 net54 _006_ VGND VGND VPWR VPWR _008_ sky130_fd_sc_hd__o211ai_1
X_628_ _179_ _181_ _196_ VGND VGND VPWR VPWR _198_ sky130_fd_sc_hd__a21oi_1
X_559_ _082_ _085_ _104_ _105_ _130_ VGND VGND VPWR VPWR _132_ sky130_fd_sc_hd__a311o_1
XFILLER_8_161 VPWR VGND VPWR VGND sky130_ef_sc_hd__decap_12
XFILLER_12_89 VGND VGND VPWR VPWR sky130_fd_sc_hd__fill_1
XFILLER_12_56 VPWR VGND VPWR VGND sky130_ef_sc_hd__decap_12
X_413_ net105 _360_ VGND VGND VPWR VPWR _368_ sky130_fd_sc_hd__nor2_4
XTAP_TAPCELL_ROW_11_100 VGND VPWR sky130_fd_sc_hd__tapvpwrvgnd_1
XPHY_EDGE_ROW_20_Left_52 VGND VGND VPWR VPWR sky130_fd_sc_hd__decap_3
XFILLER_23_55 VGND VGND VPWR VPWR sky130_fd_sc_hd__fill_1
XFILLER_0_15 VGND VGND VPWR VPWR sky130_fd_sc_hd__fill_2
XFILLER_2_167 VPWR VGND VPWR VGND sky130_ef_sc_hd__decap_12
XFILLER_3_3 VPWR VGND VPWR VGND sky130_ef_sc_hd__decap_12
X_730_ _256_ _294_ _274_ VGND VGND VPWR VPWR _295_ sky130_fd_sc_hd__a21o_1
XFILLER_29_43 VGND VGND VPWR VPWR sky130_fd_sc_hd__decap_4
XFILLER_28_163 VPWR VGND VPWR VGND sky130_ef_sc_hd__decap_12
XFILLER_28_141 VPWR VGND VPWR VGND sky130_ef_sc_hd__decap_12
X_661_ _222_ _226_ _229_ VGND VGND VPWR VPWR _230_ sky130_fd_sc_hd__and3_1
X_592_ net91 net93 net95 net15 net81 net75 VGND VGND VPWR VPWR _164_ sky130_fd_sc_hd__mux4_1
XFILLER_31_99 VGND VGND VPWR VPWR sky130_fd_sc_hd__fill_2
X_644_ _180_ _196_ VGND VGND VPWR VPWR _213_ sky130_fd_sc_hd__or2_1
XFILLER_25_155 VGND VGND VPWR VPWR sky130_fd_sc_hd__fill_2
XFILLER_25_133 VPWR VGND VPWR VGND sky130_ef_sc_hd__decap_12
XFILLER_25_111 VGND VGND VPWR VPWR sky130_fd_sc_hd__fill_1
X_713_ net60 _268_ net58 VGND VGND VPWR VPWR _279_ sky130_fd_sc_hd__o21ai_1
X_575_ net94 _099_ net92 VGND VGND VPWR VPWR _148_ sky130_fd_sc_hd__a21oi_1
Xoutput44 net44 VGND VGND VPWR VPWR ALU_result[1] sky130_fd_sc_hd__buf_2
XFILLER_31_169 VPWR VGND VPWR VGND sky130_ef_sc_hd__decap_12
XFILLER_31_147 VGND VGND VPWR VPWR sky130_fd_sc_hd__decap_3
XFILLER_26_33 VGND VGND VPWR VPWR sky130_fd_sc_hd__fill_1
XFILLER_22_169 VPWR VGND VPWR VGND sky130_ef_sc_hd__decap_12
XFILLER_13_169 VPWR VGND VPWR VGND sky130_ef_sc_hd__decap_12
XFILLER_13_147 VGND VGND VPWR VPWR sky130_fd_sc_hd__decap_4
XFILLER_9_107 VGND VGND VPWR VPWR sky130_fd_sc_hd__decap_4
X_627_ _179_ _181_ _196_ VGND VGND VPWR VPWR _197_ sky130_fd_sc_hd__and3_1
X_558_ _082_ _105_ _104_ VGND VGND VPWR VPWR _131_ sky130_fd_sc_hd__o21a_1
XFILLER_3_15 VPWR VGND VPWR VGND sky130_ef_sc_hd__decap_12
X_489_ net97 net98 net100 net5 net81 net75 VGND VGND VPWR VPWR _065_ sky130_fd_sc_hd__mux4_1
XFILLER_8_173 VPWR VGND VPWR VGND sky130_ef_sc_hd__decap_12
XFILLER_12_68 VGND VGND VPWR VPWR sky130_fd_sc_hd__decap_8
XFILLER_10_106 VGND VGND VPWR VPWR sky130_fd_sc_hd__fill_1
XTAP_TAPCELL_ROW_11_101 VGND VPWR sky130_fd_sc_hd__tapvpwrvgnd_1
X_412_ net88 net104 net3 net4 VGND VGND VPWR VPWR _367_ sky130_fd_sc_hd__or4b_4
XFILLER_2_179 VGND VGND VPWR VPWR sky130_fd_sc_hd__decap_8
Xfanout90 net18 VGND VGND VPWR VPWR net90 sky130_fd_sc_hd__buf_2
XFILLER_9_25 VPWR VGND VPWR VGND sky130_ef_sc_hd__decap_12
XFILLER_18_78 VGND VGND VPWR VPWR sky130_fd_sc_hd__fill_1
XFILLER_18_45 VGND VGND VPWR VPWR sky130_fd_sc_hd__decap_8
XFILLER_28_175 VPWR VGND VPWR VGND sky130_ef_sc_hd__decap_12
XFILLER_28_153 VGND VGND VPWR VPWR sky130_fd_sc_hd__fill_2
X_660_ _367_ _227_ _228_ VGND VGND VPWR VPWR _229_ sky130_fd_sc_hd__or3_1
X_591_ net90 net34 _368_ _161_ _162_ VGND VGND VPWR VPWR _163_ sky130_fd_sc_hd__a311o_1
XFILLER_25_189 VGND VGND VPWR VPWR sky130_fd_sc_hd__fill_1
XFILLER_25_145 VGND VGND VPWR VPWR sky130_fd_sc_hd__fill_2
X_712_ net60 _268_ VGND VGND VPWR VPWR _278_ sky130_fd_sc_hd__and2_1
Xoutput45 net45 VGND VGND VPWR VPWR ALU_result[2] sky130_fd_sc_hd__buf_2
XFILLER_31_104 VGND VGND VPWR VPWR sky130_fd_sc_hd__decap_4
X_643_ _336_ _210_ VGND VGND VPWR VPWR _212_ sky130_fd_sc_hd__xnor2_1
X_574_ _146_ _360_ _145_ VGND VGND VPWR VPWR _147_ sky130_fd_sc_hd__mux2_1
XFILLER_16_189 VGND VGND VPWR VPWR sky130_fd_sc_hd__fill_1
XFILLER_26_67 VGND VGND VPWR VPWR sky130_fd_sc_hd__fill_1
XFILLER_7_80 VGND VGND VPWR VPWR sky130_fd_sc_hd__fill_1
X_626_ _335_ _195_ VGND VGND VPWR VPWR _196_ sky130_fd_sc_hd__xnor2_1
XTAP_TAPCELL_ROW_14_110 VGND VPWR sky130_fd_sc_hd__tapvpwrvgnd_1
X_557_ net92 _128_ VGND VGND VPWR VPWR _130_ sky130_fd_sc_hd__xnor2_1
X_488_ _036_ _062_ _063_ _049_ VGND VGND VPWR VPWR _064_ sky130_fd_sc_hd__a22o_1
XFILLER_12_170 VPWR VGND VPWR VGND sky130_ef_sc_hd__decap_12
XFILLER_12_25 VGND VGND VPWR VPWR sky130_fd_sc_hd__decap_3
XFILLER_8_141 VGND VGND VPWR VPWR sky130_fd_sc_hd__decap_8
XFILLER_8_185 VGND VGND VPWR VPWR sky130_fd_sc_hd__decap_4
XTAP_TAPCELL_ROW_11_102 VGND VPWR sky130_fd_sc_hd__tapvpwrvgnd_1
X_411_ net88 net104 net3 net4 VGND VGND VPWR VPWR _366_ sky130_fd_sc_hd__nor4b_2
XFILLER_5_144 VGND VGND VPWR VPWR sky130_fd_sc_hd__decap_3
X_609_ _334_ _178_ VGND VGND VPWR VPWR _180_ sky130_fd_sc_hd__xnor2_1
XFILLER_23_57 VPWR VGND VPWR VGND sky130_ef_sc_hd__decap_12
XFILLER_2_114 VGND VGND VPWR VPWR sky130_fd_sc_hd__fill_1
XFILLER_2_125 VGND VGND VPWR VPWR sky130_fd_sc_hd__decap_4
XFILLER_2_147 VGND VGND VPWR VPWR sky130_fd_sc_hd__fill_1
Xfanout91 net18 VGND VGND VPWR VPWR net91 sky130_fd_sc_hd__buf_1
Xfanout80 net28 VGND VGND VPWR VPWR net80 sky130_fd_sc_hd__clkbuf_2
XFILLER_13_90 VGND VGND VPWR VPWR sky130_fd_sc_hd__decap_4
XFILLER_9_37 VGND VGND VPWR VPWR sky130_fd_sc_hd__fill_1
XFILLER_28_187 VGND VGND VPWR VPWR sky130_fd_sc_hd__decap_3
X_590_ net68 net102 _049_ VGND VGND VPWR VPWR _162_ sky130_fd_sc_hd__and3_2
XFILLER_19_154 VGND VGND VPWR VPWR sky130_fd_sc_hd__decap_6
XFILLER_31_57 VGND VGND VPWR VPWR sky130_fd_sc_hd__fill_2
Xoutput46 net46 VGND VGND VPWR VPWR ALU_result[3] sky130_fd_sc_hd__buf_2
X_642_ _336_ _210_ VGND VGND VPWR VPWR _211_ sky130_fd_sc_hd__nor2_1
X_711_ _253_ _256_ _275_ _371_ VGND VGND VPWR VPWR _277_ sky130_fd_sc_hd__a31o_1
XPHY_EDGE_ROW_28_Right_28 VGND VGND VPWR VPWR sky130_fd_sc_hd__decap_3
XPHY_EDGE_ROW_19_Right_19 VGND VGND VPWR VPWR sky130_fd_sc_hd__decap_3
XFILLER_16_179 VGND VGND VPWR VPWR sky130_fd_sc_hd__fill_1
X_573_ net92 net33 net54 VGND VGND VPWR VPWR _146_ sky130_fd_sc_hd__o21ai_1
XFILLER_7_92 VPWR VGND VPWR VGND sky130_ef_sc_hd__decap_12
X_625_ net36 _194_ VGND VGND VPWR VPWR _195_ sky130_fd_sc_hd__xnor2_1
XTAP_TAPCELL_ROW_14_111 VGND VPWR sky130_fd_sc_hd__tapvpwrvgnd_1
X_556_ net92 _128_ VGND VGND VPWR VPWR _129_ sky130_fd_sc_hd__nand2_1
XFILLER_12_182 VGND VGND VPWR VPWR sky130_fd_sc_hd__decap_4
X_487_ _050_ _061_ VGND VGND VPWR VPWR _063_ sky130_fd_sc_hd__or2_1
X_410_ net71 net82 net76 VGND VGND VPWR VPWR _365_ sky130_fd_sc_hd__nor3_1
X_608_ _334_ _178_ VGND VGND VPWR VPWR _179_ sky130_fd_sc_hd__or2_1
X_539_ net71 _110_ _112_ _361_ VGND VGND VPWR VPWR _113_ sky130_fd_sc_hd__o211ai_2
XFILLER_23_69 VGND VGND VPWR VPWR sky130_fd_sc_hd__decap_4
XPHY_EDGE_ROW_24_Left_56 VGND VGND VPWR VPWR sky130_fd_sc_hd__decap_3
Xfanout92 net17 VGND VGND VPWR VPWR net92 sky130_fd_sc_hd__buf_2
XFILLER_0_29 VGND VGND VPWR VPWR sky130_fd_sc_hd__fill_2
Xfanout70 net30 VGND VGND VPWR VPWR net70 sky130_fd_sc_hd__clkbuf_2
XFILLER_2_137 VGND VGND VPWR VPWR sky130_fd_sc_hd__decap_3
Xfanout81 net84 VGND VGND VPWR VPWR net81 sky130_fd_sc_hd__clkbuf_4
XFILLER_1_181 VGND VGND VPWR VPWR sky130_fd_sc_hd__decap_8
XFILLER_1_3 VPWR VGND VPWR VGND sky130_ef_sc_hd__decap_12
XFILLER_20_26 VGND VGND VPWR VPWR sky130_fd_sc_hd__fill_2
XFILLER_10_92 VGND VGND VPWR VPWR sky130_fd_sc_hd__decap_3
XFILLER_25_169 VPWR VGND VPWR VGND sky130_ef_sc_hd__decap_12
XPHY_EDGE_ROW_11_Left_43 VGND VGND VPWR VPWR sky130_fd_sc_hd__decap_3
X_641_ net22 _209_ VGND VGND VPWR VPWR _210_ sky130_fd_sc_hd__xor2_1
X_710_ _253_ _256_ _275_ VGND VGND VPWR VPWR _276_ sky130_fd_sc_hd__a21oi_1
X_572_ net105 net92 net33 VGND VGND VPWR VPWR _145_ sky130_fd_sc_hd__and3b_1
Xoutput47 net47 VGND VGND VPWR VPWR ALU_result[4] sky130_fd_sc_hd__buf_2
XFILLER_22_139 VGND VGND VPWR VPWR sky130_fd_sc_hd__fill_1
XTAP_TAPCELL_ROW_17_120 VGND VPWR sky130_fd_sc_hd__tapvpwrvgnd_1
XFILLER_26_25 VGND VGND VPWR VPWR sky130_fd_sc_hd__decap_3
XFILLER_21_172 VPWR VGND VPWR VGND sky130_ef_sc_hd__decap_12
XFILLER_13_139 VGND VGND VPWR VPWR sky130_fd_sc_hd__fill_1
X_624_ net35 _176_ net56 VGND VGND VPWR VPWR _194_ sky130_fd_sc_hd__o21ai_1
X_555_ net33 _127_ VGND VGND VPWR VPWR _128_ sky130_fd_sc_hd__xnor2_1
X_486_ net72 net101 _364_ _061_ VGND VGND VPWR VPWR _062_ sky130_fd_sc_hd__a31o_1
XFILLER_12_16 VGND VGND VPWR VPWR sky130_fd_sc_hd__fill_1
X_607_ net35 _177_ VGND VGND VPWR VPWR _178_ sky130_fd_sc_hd__xnor2_1
X_538_ net75 _003_ net71 VGND VGND VPWR VPWR _112_ sky130_fd_sc_hd__o21ai_1
X_469_ _366_ _044_ _045_ VGND VGND VPWR VPWR _046_ sky130_fd_sc_hd__and3_1
Xfanout60 net61 VGND VGND VPWR VPWR net60 sky130_fd_sc_hd__clkbuf_2
Xfanout93 net17 VGND VGND VPWR VPWR net93 sky130_fd_sc_hd__buf_1
Xfanout71 net74 VGND VGND VPWR VPWR net71 sky130_fd_sc_hd__buf_2
Xfanout82 net84 VGND VGND VPWR VPWR net82 sky130_fd_sc_hd__clkbuf_2
XFILLER_27_3 VGND VGND VPWR VPWR sky130_fd_sc_hd__fill_2
XFILLER_28_112 VGND VGND VPWR VPWR sky130_fd_sc_hd__decap_3
XFILLER_19_189 VGND VGND VPWR VPWR sky130_fd_sc_hd__fill_1
XFILLER_19_167 VGND VGND VPWR VPWR sky130_fd_sc_hd__fill_1
XFILLER_6_18 VGND VGND VPWR VPWR sky130_fd_sc_hd__decap_6
XFILLER_6_29 VGND VGND VPWR VPWR sky130_fd_sc_hd__decap_4
XFILLER_31_15 VPWR VGND VPWR VGND sky130_ef_sc_hd__decap_12
X_640_ net35 net36 _176_ net56 VGND VGND VPWR VPWR _209_ sky130_fd_sc_hd__o31a_1
X_571_ net68 _142_ _143_ _139_ VGND VGND VPWR VPWR _144_ sky130_fd_sc_hd__a31o_1
XPHY_EDGE_ROW_1_Right_1 VGND VGND VPWR VPWR sky130_fd_sc_hd__decap_3
Xoutput37 net37 VGND VGND VPWR VPWR ALU_result[0] sky130_fd_sc_hd__buf_2
Xoutput48 net48 VGND VGND VPWR VPWR ALU_result[5] sky130_fd_sc_hd__buf_2
XFILLER_21_184 VGND VGND VPWR VPWR sky130_fd_sc_hd__decap_3
X_623_ _181_ _182_ _191_ _193_ VGND VGND VPWR VPWR net51 sky130_fd_sc_hd__a211o_1
X_554_ net31 net32 _078_ net56 VGND VGND VPWR VPWR _127_ sky130_fd_sc_hd__o31a_1
X_485_ net72 _060_ VGND VGND VPWR VPWR _061_ sky130_fd_sc_hd__and2b_1
XTAP_TAPCELL_ROW_20_127 VGND VPWR sky130_fd_sc_hd__tapvpwrvgnd_1
XFILLER_5_136 VGND VGND VPWR VPWR sky130_fd_sc_hd__decap_8
XFILLER_5_169 VPWR VGND VPWR VGND sky130_ef_sc_hd__decap_12
X_606_ net56 _176_ VGND VGND VPWR VPWR _177_ sky130_fd_sc_hd__nand2_1
X_399_ net5 net81 VGND VGND VPWR VPWR _354_ sky130_fd_sc_hd__nand2_1
XFILLER_4_95 VGND VGND VPWR VPWR sky130_fd_sc_hd__decap_6
X_537_ _110_ VGND VGND VPWR VPWR _111_ sky130_fd_sc_hd__inv_2
X_468_ net12 net99 VGND VGND VPWR VPWR _045_ sky130_fd_sc_hd__or2_1
XFILLER_9_18 VGND VGND VPWR VPWR sky130_fd_sc_hd__fill_1
XFILLER_29_7 VPWR VGND VPWR VGND sky130_ef_sc_hd__decap_12
Xfanout61 net9 VGND VGND VPWR VPWR net61 sky130_fd_sc_hd__clkbuf_2
Xfanout83 net84 VGND VGND VPWR VPWR net83 sky130_fd_sc_hd__clkbuf_4
Xfanout72 net73 VGND VGND VPWR VPWR net72 sky130_fd_sc_hd__clkbuf_2
XTAP_TAPCELL_ROW_9_94 VGND VPWR sky130_fd_sc_hd__tapvpwrvgnd_1
Xfanout94 net95 VGND VGND VPWR VPWR net94 sky130_fd_sc_hd__clkbuf_2
XFILLER_18_27 VGND VGND VPWR VPWR sky130_fd_sc_hd__fill_1
XFILLER_1_63 VGND VGND VPWR VPWR sky130_fd_sc_hd__decap_6
XFILLER_19_113 VGND VGND VPWR VPWR sky130_fd_sc_hd__decap_4
XFILLER_10_83 VGND VGND VPWR VPWR sky130_fd_sc_hd__fill_1
XFILLER_19_124 VGND VGND VPWR VPWR sky130_fd_sc_hd__decap_4
Xoutput38 net38 VGND VGND VPWR VPWR ALU_result[10] sky130_fd_sc_hd__buf_2
XFILLER_31_27 VGND VGND VPWR VPWR sky130_fd_sc_hd__fill_1
XFILLER_15_39 VGND VGND VPWR VPWR sky130_fd_sc_hd__decap_3
Xoutput49 net49 VGND VGND VPWR VPWR ALU_result[6] sky130_fd_sc_hd__buf_2
X_570_ _037_ _140_ VGND VGND VPWR VPWR _143_ sky130_fd_sc_hd__or2_1
X_768_ net42 _316_ _325_ _330_ VGND VGND VPWR VPWR net53 sky130_fd_sc_hd__and4b_1
X_699_ net63 net24 _368_ _162_ _265_ VGND VGND VPWR VPWR _266_ sky130_fd_sc_hd__a311o_1
XPHY_EDGE_ROW_24_Right_24 VGND VGND VPWR VPWR sky130_fd_sc_hd__decap_3
XTAP_TAPCELL_ROW_23_136 VGND VPWR sky130_fd_sc_hd__tapvpwrvgnd_1
XPHY_EDGE_ROW_15_Right_15 VGND VGND VPWR VPWR sky130_fd_sc_hd__decap_3
X_622_ net89 _158_ _192_ net58 VGND VGND VPWR VPWR _193_ sky130_fd_sc_hd__o211a_1
X_484_ net65 net62 net60 net103 net86 net80 VGND VGND VPWR VPWR _060_ sky130_fd_sc_hd__mux4_1
XFILLER_12_141 VGND VGND VPWR VPWR sky130_fd_sc_hd__decap_4
X_553_ _370_ _108_ _109_ _126_ VGND VGND VPWR VPWR net48 sky130_fd_sc_hd__a31o_1
XFILLER_8_189 VGND VGND VPWR VPWR sky130_fd_sc_hd__fill_1
XTAP_TAPCELL_ROW_20_128 VGND VPWR sky130_fd_sc_hd__tapvpwrvgnd_1
X_605_ net31 net32 _078_ _175_ VGND VGND VPWR VPWR _176_ sky130_fd_sc_hd__or4_2
X_536_ net95 net96 net97 net98 net81 net75 VGND VGND VPWR VPWR _110_ sky130_fd_sc_hd__mux4_1
X_398_ _340_ _352_ VGND VGND VPWR VPWR _353_ sky130_fd_sc_hd__nor2_1
X_467_ net12 net99 VGND VGND VPWR VPWR _044_ sky130_fd_sc_hd__nand2_1
Xfanout62 net8 VGND VGND VPWR VPWR net62 sky130_fd_sc_hd__clkbuf_2
XFILLER_13_94 VGND VGND VPWR VPWR sky130_fd_sc_hd__fill_1
XFILLER_13_50 VGND VGND VPWR VPWR sky130_fd_sc_hd__fill_2
Xfanout95 net16 VGND VGND VPWR VPWR net95 sky130_fd_sc_hd__clkbuf_2
XTAP_TAPCELL_ROW_0_64 VGND VPWR sky130_fd_sc_hd__tapvpwrvgnd_1
Xfanout84 net86 VGND VGND VPWR VPWR net84 sky130_fd_sc_hd__buf_2
Xfanout73 net74 VGND VGND VPWR VPWR net73 sky130_fd_sc_hd__buf_2
XTAP_TAPCELL_ROW_9_95 VGND VPWR sky130_fd_sc_hd__tapvpwrvgnd_1
X_519_ net72 _037_ _343_ VGND VGND VPWR VPWR _094_ sky130_fd_sc_hd__or3b_1
XFILLER_24_93 VGND VGND VPWR VPWR sky130_fd_sc_hd__fill_2
XFILLER_24_71 VGND VGND VPWR VPWR sky130_fd_sc_hd__fill_2
XFILLER_20_29 VPWR VGND VPWR VGND sky130_ef_sc_hd__decap_12
XFILLER_20_18 VGND VGND VPWR VPWR sky130_fd_sc_hd__decap_8
XFILLER_1_75 VGND VGND VPWR VPWR sky130_fd_sc_hd__decap_4
XFILLER_1_31 VGND VGND VPWR VPWR sky130_fd_sc_hd__fill_1
XFILLER_28_136 VGND VGND VPWR VPWR sky130_fd_sc_hd__decap_4
XFILLER_28_103 VGND VGND VPWR VPWR sky130_fd_sc_hd__fill_1
XFILLER_19_169 VPWR VGND VPWR VGND sky130_ef_sc_hd__decap_12
XTAP_TAPCELL_ROW_6_85 VGND VPWR sky130_fd_sc_hd__tapvpwrvgnd_1
Xoutput39 net39 VGND VGND VPWR VPWR ALU_result[11] sky130_fd_sc_hd__buf_2
X_767_ net39 net41 _328_ _329_ VGND VGND VPWR VPWR _330_ sky130_fd_sc_hd__nor4b_1
XTAP_TAPCELL_ROW_26_145 VGND VPWR sky130_fd_sc_hd__tapvpwrvgnd_1
XFILLER_16_106 VGND VGND VPWR VPWR sky130_fd_sc_hd__decap_4
XFILLER_26_39 VPWR VGND VPWR VGND sky130_ef_sc_hd__decap_12
X_698_ net63 net24 net54 _264_ VGND VGND VPWR VPWR _265_ sky130_fd_sc_hd__o211a_1
XFILLER_15_161 VGND VGND VPWR VPWR sky130_fd_sc_hd__fill_1
XPHY_EDGE_ROW_15_Left_47 VGND VGND VPWR VPWR sky130_fd_sc_hd__decap_3
XFILLER_13_109 VGND VGND VPWR VPWR sky130_fd_sc_hd__decap_3
XTAP_TAPCELL_ROW_23_137 VGND VPWR sky130_fd_sc_hd__tapvpwrvgnd_1
X_621_ net89 _158_ VGND VGND VPWR VPWR _192_ sky130_fd_sc_hd__nand2_1
X_483_ _056_ _058_ VGND VGND VPWR VPWR _059_ sky130_fd_sc_hd__xnor2_1
X_552_ _125_ _120_ VGND VGND VPWR VPWR _126_ sky130_fd_sc_hd__nand2b_1
XTAP_TAPCELL_ROW_20_129 VGND VPWR sky130_fd_sc_hd__tapvpwrvgnd_1
XFILLER_12_186 VGND VGND VPWR VPWR sky130_fd_sc_hd__fill_1
X_604_ net33 net34 VGND VGND VPWR VPWR _175_ sky130_fd_sc_hd__or2_1
X_397_ net67 _344_ _351_ VGND VGND VPWR VPWR _352_ sky130_fd_sc_hd__a21oi_1
X_466_ net73 net99 net54 _042_ VGND VGND VPWR VPWR _043_ sky130_fd_sc_hd__o211a_1
X_535_ _082_ _085_ _107_ VGND VGND VPWR VPWR _109_ sky130_fd_sc_hd__a21o_1
XPHY_EDGE_ROW_18_Left_50 VGND VGND VPWR VPWR sky130_fd_sc_hd__decap_3
XFILLER_4_75 VGND VGND VPWR VPWR sky130_fd_sc_hd__fill_1
Xfanout63 net8 VGND VGND VPWR VPWR net63 sky130_fd_sc_hd__buf_1
XTAP_TAPCELL_ROW_0_65 VGND VPWR sky130_fd_sc_hd__tapvpwrvgnd_1
Xfanout96 net15 VGND VGND VPWR VPWR net96 sky130_fd_sc_hd__buf_2
Xfanout85 net86 VGND VGND VPWR VPWR net85 sky130_fd_sc_hd__buf_2
Xfanout74 net29 VGND VGND VPWR VPWR net74 sky130_fd_sc_hd__clkbuf_2
XFILLER_18_29 VGND VGND VPWR VPWR sky130_fd_sc_hd__fill_1
X_518_ _049_ _092_ VGND VGND VPWR VPWR _093_ sky130_fd_sc_hd__nand2_1
X_449_ net98 _024_ VGND VGND VPWR VPWR _026_ sky130_fd_sc_hd__xor2_2
XTAP_TAPCELL_ROW_9_96 VGND VPWR sky130_fd_sc_hd__tapvpwrvgnd_1
XPHY_EDGE_ROW_3_Left_35 VGND VGND VPWR VPWR sky130_fd_sc_hd__decap_3
XTAP_TAPCELL_ROW_29_154 VGND VPWR sky130_fd_sc_hd__tapvpwrvgnd_1
XFILLER_27_181 VGND VGND VPWR VPWR sky130_fd_sc_hd__decap_8
XFILLER_19_104 VGND VGND VPWR VPWR sky130_fd_sc_hd__fill_1
XTAP_TAPCELL_ROW_6_86 VGND VPWR sky130_fd_sc_hd__tapvpwrvgnd_1
XFILLER_31_29 VPWR VGND VPWR VGND sky130_ef_sc_hd__decap_12
XFILLER_25_3 VGND VGND VPWR VPWR sky130_fd_sc_hd__decap_4
XFILLER_18_170 VGND VGND VPWR VPWR sky130_fd_sc_hd__decap_8
XTAP_TAPCELL_ROW_26_146 VGND VPWR sky130_fd_sc_hd__tapvpwrvgnd_1
XFILLER_24_162 VPWR VGND VPWR VGND sky130_ef_sc_hd__decap_12
XFILLER_21_95 VPWR VGND VPWR VGND sky130_ef_sc_hd__decap_12
XFILLER_30_154 VPWR VGND VPWR VGND sky130_ef_sc_hd__decap_12
XFILLER_30_121 VGND VGND VPWR VPWR sky130_fd_sc_hd__decap_3
X_766_ net52 net38 _258_ _270_ VGND VGND VPWR VPWR _329_ sky130_fd_sc_hd__and4bb_1
X_697_ net106 net63 net24 VGND VGND VPWR VPWR _264_ sky130_fd_sc_hd__nand3b_1
XTAP_TAPCELL_ROW_31_160 VGND VPWR sky130_fd_sc_hd__tapvpwrvgnd_1
XFILLER_26_29 VGND VGND VPWR VPWR sky130_fd_sc_hd__decap_4
XTAP_TAPCELL_ROW_23_138 VGND VPWR sky130_fd_sc_hd__tapvpwrvgnd_1
XFILLER_21_121 VGND VGND VPWR VPWR sky130_fd_sc_hd__decap_8
X_620_ _162_ _188_ _189_ _190_ VGND VGND VPWR VPWR _191_ sky130_fd_sc_hd__or4_1
XPHY_EDGE_ROW_5_Right_5 VGND VGND VPWR VPWR sky130_fd_sc_hd__decap_3
X_551_ net94 net32 _368_ _122_ _124_ VGND VGND VPWR VPWR _125_ sky130_fd_sc_hd__a311o_1
X_749_ _311_ _312_ VGND VGND VPWR VPWR _313_ sky130_fd_sc_hd__xnor2_1
X_482_ _055_ _057_ VGND VGND VPWR VPWR _058_ sky130_fd_sc_hd__or2_1
XTAP_TAPCELL_ROW_3_76 VGND VPWR sky130_fd_sc_hd__tapvpwrvgnd_1
XFILLER_27_72 VPWR VGND VPWR VGND sky130_ef_sc_hd__decap_12
XFILLER_27_50 VGND VGND VPWR VPWR sky130_fd_sc_hd__decap_6
X_603_ _131_ _169_ _173_ VGND VGND VPWR VPWR _174_ sky130_fd_sc_hd__o21a_1
X_396_ _345_ _347_ _348_ _350_ VGND VGND VPWR VPWR _351_ sky130_fd_sc_hd__a22o_1
X_465_ net106 net73 net99 VGND VGND VPWR VPWR _042_ sky130_fd_sc_hd__nand3b_1
X_534_ _082_ _085_ _107_ VGND VGND VPWR VPWR _108_ sky130_fd_sc_hd__nand3_1
Xfanout64 net7 VGND VGND VPWR VPWR net64 sky130_fd_sc_hd__buf_2
XFILLER_13_30 VPWR VGND VPWR VGND sky130_ef_sc_hd__decap_12
XFILLER_1_120 VGND VGND VPWR VPWR sky130_fd_sc_hd__decap_4
Xfanout75 net78 VGND VGND VPWR VPWR net75 sky130_fd_sc_hd__buf_2
Xfanout86 net21 VGND VGND VPWR VPWR net86 sky130_fd_sc_hd__clkbuf_2
Xfanout97 net14 VGND VGND VPWR VPWR net97 sky130_fd_sc_hd__clkbuf_2
X_379_ net89 VGND VGND VPWR VPWR _334_ sky130_fd_sc_hd__inv_2
X_517_ _343_ net101 net72 VGND VGND VPWR VPWR _092_ sky130_fd_sc_hd__mux2_1
X_448_ net98 _024_ VGND VGND VPWR VPWR _025_ sky130_fd_sc_hd__and2_1
XTAP_TAPCELL_ROW_0_66 VGND VPWR sky130_fd_sc_hd__tapvpwrvgnd_1
XTAP_TAPCELL_ROW_10_97 VGND VPWR sky130_fd_sc_hd__tapvpwrvgnd_1
XTAP_TAPCELL_ROW_29_155 VGND VPWR sky130_fd_sc_hd__tapvpwrvgnd_1
XTAP_TAPCELL_ROW_6_87 VGND VPWR sky130_fd_sc_hd__tapvpwrvgnd_1
XTAP_TAPCELL_ROW_26_147 VGND VPWR sky130_fd_sc_hd__tapvpwrvgnd_1
XFILLER_24_174 VGND VGND VPWR VPWR sky130_fd_sc_hd__decap_6
XFILLER_24_141 VPWR VGND VPWR VGND sky130_ef_sc_hd__decap_12
XFILLER_21_74 VGND VGND VPWR VPWR sky130_fd_sc_hd__decap_4
XFILLER_30_166 VPWR VGND VPWR VGND sky130_ef_sc_hd__decap_12
X_696_ net68 _093_ VGND VGND VPWR VPWR _263_ sky130_fd_sc_hd__or2_1
X_765_ net49 net50 net51 _327_ VGND VGND VPWR VPWR _328_ sky130_fd_sc_hd__or4b_1
XTAP_TAPCELL_ROW_31_161 VGND VPWR sky130_fd_sc_hd__tapvpwrvgnd_1
XFILLER_21_111 VGND VGND VPWR VPWR sky130_fd_sc_hd__fill_1
XPHY_EDGE_ROW_20_Right_20 VGND VGND VPWR VPWR sky130_fd_sc_hd__decap_3
XFILLER_16_41 VPWR VGND VPWR VGND sky130_ef_sc_hd__decap_12
XFILLER_12_111 VGND VGND VPWR VPWR sky130_fd_sc_hd__decap_8
XPHY_EDGE_ROW_11_Right_11 VGND VGND VPWR VPWR sky130_fd_sc_hd__decap_3
X_481_ net14 _054_ VGND VGND VPWR VPWR _057_ sky130_fd_sc_hd__nor2_1
XTAP_TAPCELL_ROW_3_77 VGND VPWR sky130_fd_sc_hd__tapvpwrvgnd_1
X_550_ net94 _099_ _123_ _366_ VGND VGND VPWR VPWR _124_ sky130_fd_sc_hd__o211a_1
X_679_ _212_ _233_ VGND VGND VPWR VPWR _246_ sky130_fd_sc_hd__nand2b_1
X_748_ net26 net57 _289_ VGND VGND VPWR VPWR _312_ sky130_fd_sc_hd__a21o_1
XFILLER_27_84 VGND VGND VPWR VPWR sky130_fd_sc_hd__decap_4
X_602_ net90 _152_ _172_ VGND VGND VPWR VPWR _173_ sky130_fd_sc_hd__o21ai_1
X_533_ _104_ _106_ VGND VGND VPWR VPWR _107_ sky130_fd_sc_hd__nand2_1
X_464_ net73 _040_ VGND VGND VPWR VPWR _041_ sky130_fd_sc_hd__nor2_1
X_395_ net96 net95 net92 net90 net81 net75 VGND VGND VPWR VPWR _350_ sky130_fd_sc_hd__mux4_1
Xfanout65 net7 VGND VGND VPWR VPWR net65 sky130_fd_sc_hd__buf_1
Xfanout87 net20 VGND VGND VPWR VPWR net87 sky130_fd_sc_hd__clkbuf_2
XFILLER_13_42 VGND VGND VPWR VPWR sky130_fd_sc_hd__fill_1
Xfanout76 net78 VGND VGND VPWR VPWR net76 sky130_fd_sc_hd__buf_1
Xfanout54 _005_ VGND VGND VPWR VPWR net54 sky130_fd_sc_hd__clkbuf_4
Xfanout98 net13 VGND VGND VPWR VPWR net98 sky130_fd_sc_hd__buf_2
X_516_ _339_ _090_ VGND VGND VPWR VPWR _091_ sky130_fd_sc_hd__nand2_1
XTAP_TAPCELL_ROW_0_67 VGND VPWR sky130_fd_sc_hd__tapvpwrvgnd_1
X_378_ net100 VGND VGND VPWR VPWR _333_ sky130_fd_sc_hd__inv_2
X_447_ net73 _023_ VGND VGND VPWR VPWR _024_ sky130_fd_sc_hd__xnor2_1
XFILLER_24_63 VGND VGND VPWR VPWR sky130_fd_sc_hd__decap_8
XFILLER_29_19 VPWR VGND VPWR VGND sky130_ef_sc_hd__decap_12
XTAP_TAPCELL_ROW_29_156 VGND VPWR sky130_fd_sc_hd__tapvpwrvgnd_1
XFILLER_27_161 VGND VGND VPWR VPWR sky130_fd_sc_hd__decap_6
XFILLER_19_128 VGND VGND VPWR VPWR sky130_fd_sc_hd__fill_1
XFILLER_19_96 VGND VGND VPWR VPWR sky130_fd_sc_hd__decap_8
XFILLER_19_52 VGND VGND VPWR VPWR sky130_fd_sc_hd__decap_4
XTAP_TAPCELL_ROW_10_98 VGND VPWR sky130_fd_sc_hd__tapvpwrvgnd_1
XFILLER_10_10 VGND VGND VPWR VPWR sky130_fd_sc_hd__fill_2
XFILLER_24_153 VGND VGND VPWR VPWR sky130_fd_sc_hd__fill_2
XFILLER_30_178 VPWR VGND VPWR VGND sky130_ef_sc_hd__decap_12
X_695_ net68 _089_ _094_ _261_ VGND VGND VPWR VPWR _262_ sky130_fd_sc_hd__a22o_1
X_764_ net47 net48 _326_ VGND VGND VPWR VPWR _327_ sky130_fd_sc_hd__nor3_1
XFILLER_7_22 VGND VGND VPWR VPWR sky130_fd_sc_hd__fill_1
XTAP_TAPCELL_ROW_31_162 VGND VPWR sky130_fd_sc_hd__tapvpwrvgnd_1
XFILLER_16_53 VGND VGND VPWR VPWR sky130_fd_sc_hd__fill_2
X_480_ _022_ _026_ _025_ VGND VGND VPWR VPWR _056_ sky130_fd_sc_hd__a21o_1
XTAP_TAPCELL_ROW_3_78 VGND VPWR sky130_fd_sc_hd__tapvpwrvgnd_1
XFILLER_8_105 VPWR VGND VPWR VGND sky130_ef_sc_hd__decap_12
XFILLER_8_149 VGND VGND VPWR VPWR sky130_fd_sc_hd__decap_3
X_678_ _370_ _234_ _235_ _245_ VGND VGND VPWR VPWR net39 sky130_fd_sc_hd__a31o_1
X_747_ _309_ _310_ VGND VGND VPWR VPWR _311_ sky130_fd_sc_hd__nand2_1
X_601_ net92 _128_ _152_ net90 VGND VGND VPWR VPWR _172_ sky130_fd_sc_hd__a22o_1
X_394_ _332_ net71 VGND VGND VPWR VPWR _349_ sky130_fd_sc_hd__nand2_1
X_463_ net79 _038_ _039_ VGND VGND VPWR VPWR _040_ sky130_fd_sc_hd__o21ai_1
X_532_ _105_ VGND VGND VPWR VPWR _106_ sky130_fd_sc_hd__inv_2
Xfanout55 _005_ VGND VGND VPWR VPWR net55 sky130_fd_sc_hd__dlymetal6s2s_1
Xfanout66 net6 VGND VGND VPWR VPWR net66 sky130_fd_sc_hd__clkbuf_2
X_377_ net68 VGND VGND VPWR VPWR _332_ sky130_fd_sc_hd__inv_2
XFILLER_13_98 VGND VGND VPWR VPWR sky130_fd_sc_hd__fill_1
X_515_ _341_ _349_ _350_ _346_ VGND VGND VPWR VPWR _090_ sky130_fd_sc_hd__o22a_1
Xfanout77 net78 VGND VGND VPWR VPWR net77 sky130_fd_sc_hd__buf_2
XFILLER_1_166 VGND VGND VPWR VPWR sky130_fd_sc_hd__fill_2
XTAP_TAPCELL_ROW_0_68 VGND VPWR sky130_fd_sc_hd__tapvpwrvgnd_1
Xfanout88 net2 VGND VGND VPWR VPWR net88 sky130_fd_sc_hd__buf_2
X_446_ _364_ net57 VGND VGND VPWR VPWR _023_ sky130_fd_sc_hd__and2b_1
Xfanout99 net13 VGND VGND VPWR VPWR net99 sky130_fd_sc_hd__buf_1
XFILLER_8_3 VPWR VGND VPWR VGND sky130_ef_sc_hd__decap_12
XFILLER_24_53 VGND VGND VPWR VPWR sky130_fd_sc_hd__fill_1
XFILLER_27_9 VPWR VGND VPWR VGND sky130_ef_sc_hd__decap_12
X_429_ net100 _367_ _006_ _360_ VGND VGND VPWR VPWR _007_ sky130_fd_sc_hd__o22a_1
XTAP_TAPCELL_ROW_10_99 VGND VPWR sky130_fd_sc_hd__tapvpwrvgnd_1
Xinput1 ALU_control[0] VGND VGND VPWR VPWR net1 sky130_fd_sc_hd__clkbuf_1
XPHY_EDGE_ROW_7_Left_39 VGND VGND VPWR VPWR sky130_fd_sc_hd__decap_3
XFILLER_21_87 VGND VGND VPWR VPWR sky130_fd_sc_hd__fill_2
XFILLER_21_65 VGND VGND VPWR VPWR sky130_fd_sc_hd__decap_3
XFILLER_15_165 VGND VGND VPWR VPWR sky130_fd_sc_hd__decap_3
X_694_ _361_ _260_ VGND VGND VPWR VPWR _261_ sky130_fd_sc_hd__nand2_1
X_763_ net37 net44 net45 net46 VGND VGND VPWR VPWR _326_ sky130_fd_sc_hd__or4_1
XTAP_TAPCELL_ROW_31_163 VGND VPWR sky130_fd_sc_hd__tapvpwrvgnd_1
XFILLER_21_113 VGND VGND VPWR VPWR sky130_fd_sc_hd__decap_4
XFILLER_16_76 VGND VGND VPWR VPWR sky130_fd_sc_hd__decap_8
XFILLER_16_21 VGND VGND VPWR VPWR sky130_fd_sc_hd__decap_6
XFILLER_8_117 VGND VGND VPWR VPWR sky130_fd_sc_hd__decap_8
XFILLER_8_128 VPWR VGND VPWR VGND sky130_ef_sc_hd__decap_12
X_677_ _332_ _064_ _237_ _244_ VGND VGND VPWR VPWR _245_ sky130_fd_sc_hd__a211o_1
X_746_ net102 net27 VGND VGND VPWR VPWR _310_ sky130_fd_sc_hd__or2_1
XFILLER_7_172 VPWR VGND VPWR VGND sky130_ef_sc_hd__decap_12
XPHY_EDGE_ROW_9_Right_9 VGND VGND VPWR VPWR sky130_fd_sc_hd__decap_3
XFILLER_5_109 VGND VGND VPWR VPWR sky130_fd_sc_hd__decap_3
X_600_ _057_ _084_ _169_ _170_ VGND VGND VPWR VPWR _171_ sky130_fd_sc_hd__or4_2
X_531_ net94 _103_ VGND VGND VPWR VPWR _105_ sky130_fd_sc_hd__nor2_1
X_393_ _332_ net71 VGND VGND VPWR VPWR _348_ sky130_fd_sc_hd__and2_2
XFILLER_4_57 VPWR VGND VPWR VGND sky130_ef_sc_hd__decap_12
XFILLER_4_131 VGND VGND VPWR VPWR sky130_fd_sc_hd__fill_2
X_462_ _331_ net85 net79 VGND VGND VPWR VPWR _039_ sky130_fd_sc_hd__o21ai_1
X_729_ net61 _272_ _253_ VGND VGND VPWR VPWR _294_ sky130_fd_sc_hd__a21boi_1
Xfanout89 net19 VGND VGND VPWR VPWR net89 sky130_fd_sc_hd__clkbuf_2
Xfanout56 net57 VGND VGND VPWR VPWR net56 sky130_fd_sc_hd__buf_2
X_514_ net74 _087_ _088_ _361_ VGND VGND VPWR VPWR _089_ sky130_fd_sc_hd__o211ai_1
XFILLER_1_189 VGND VGND VPWR VPWR sky130_fd_sc_hd__fill_1
XTAP_TAPCELL_ROW_0_69 VGND VPWR sky130_fd_sc_hd__tapvpwrvgnd_1
Xfanout67 net70 VGND VGND VPWR VPWR net67 sky130_fd_sc_hd__buf_2
Xfanout78 net28 VGND VGND VPWR VPWR net78 sky130_fd_sc_hd__clkbuf_2
X_445_ _357_ _375_ _000_ VGND VGND VPWR VPWR _022_ sky130_fd_sc_hd__a21bo_1
X_376_ net5 VGND VGND VPWR VPWR _331_ sky130_fd_sc_hd__inv_2
XPHY_EDGE_ROW_23_Left_55 VGND VGND VPWR VPWR sky130_fd_sc_hd__decap_3
X_428_ net104 _333_ net75 VGND VGND VPWR VPWR _006_ sky130_fd_sc_hd__or3b_1
XFILLER_28_119 VGND VGND VPWR VPWR sky130_fd_sc_hd__decap_3
XFILLER_10_45 VGND VGND VPWR VPWR sky130_fd_sc_hd__decap_8
Xinput2 ALU_control[1] VGND VGND VPWR VPWR net2 sky130_fd_sc_hd__clkbuf_1
XFILLER_25_7 VGND VGND VPWR VPWR sky130_fd_sc_hd__fill_1
XFILLER_19_65 VGND VGND VPWR VPWR sky130_fd_sc_hd__fill_2
XFILLER_18_141 VGND VGND VPWR VPWR sky130_fd_sc_hd__fill_2
XFILLER_18_6 VGND VGND VPWR VPWR sky130_fd_sc_hd__decap_3
X_762_ _316_ _325_ VGND VGND VPWR VPWR net43 sky130_fd_sc_hd__nand2_1
XFILLER_24_133 VGND VGND VPWR VPWR sky130_fd_sc_hd__decap_6
XFILLER_21_55 VGND VGND VPWR VPWR sky130_fd_sc_hd__fill_1
XFILLER_21_44 VGND VGND VPWR VPWR sky130_fd_sc_hd__decap_6
X_693_ _349_ _183_ _259_ _346_ VGND VGND VPWR VPWR _260_ sky130_fd_sc_hd__o22a_1
XFILLER_7_57 VGND VGND VPWR VPWR sky130_fd_sc_hd__fill_2
XTAP_TAPCELL_ROW_31_164 VGND VPWR sky130_fd_sc_hd__tapvpwrvgnd_1
XTAP_TAPCELL_ROW_14_109 VGND VPWR sky130_fd_sc_hd__tapvpwrvgnd_1
XPHY_EDGE_ROW_10_Left_42 VGND VGND VPWR VPWR sky130_fd_sc_hd__decap_3
X_676_ _162_ _240_ _242_ _243_ VGND VGND VPWR VPWR _244_ sky130_fd_sc_hd__or4_1
X_745_ net102 net27 VGND VGND VPWR VPWR _309_ sky130_fd_sc_hd__nand2_1
XFILLER_7_184 VGND VGND VPWR VPWR sky130_fd_sc_hd__decap_6
XFILLER_27_21 VGND VGND VPWR VPWR sky130_fd_sc_hd__decap_8
XFILLER_4_36 VGND VGND VPWR VPWR sky130_fd_sc_hd__fill_1
X_392_ net5 net100 net98 net97 net81 net76 VGND VGND VPWR VPWR _347_ sky130_fd_sc_hd__mux4_1
X_461_ net99 net12 net85 VGND VGND VPWR VPWR _038_ sky130_fd_sc_hd__mux2_1
X_530_ net94 _103_ VGND VGND VPWR VPWR _104_ sky130_fd_sc_hd__nand2_1
X_728_ _291_ _292_ VGND VGND VPWR VPWR _293_ sky130_fd_sc_hd__nand2_1
X_659_ net6 _200_ VGND VGND VPWR VPWR _228_ sky130_fd_sc_hd__nor2_1
XFILLER_4_69 VGND VGND VPWR VPWR sky130_fd_sc_hd__decap_6
Xfanout68 net70 VGND VGND VPWR VPWR net68 sky130_fd_sc_hd__buf_2
XFILLER_13_23 VGND VGND VPWR VPWR sky130_fd_sc_hd__decap_3
Xfanout57 _372_ VGND VGND VPWR VPWR net57 sky130_fd_sc_hd__buf_2
Xfanout79 net28 VGND VGND VPWR VPWR net79 sky130_fd_sc_hd__buf_2
X_513_ net5 _364_ net74 VGND VGND VPWR VPWR _088_ sky130_fd_sc_hd__a21bo_1
X_444_ _009_ _021_ VGND VGND VPWR VPWR net44 sky130_fd_sc_hd__nand2_1
X_427_ net88 _356_ VGND VGND VPWR VPWR _005_ sky130_fd_sc_hd__and2_1
XFILLER_1_15 VPWR VGND VPWR VGND sky130_ef_sc_hd__decap_12
XPHY_EDGE_ROW_27_Right_27 VGND VGND VPWR VPWR sky130_fd_sc_hd__decap_3
XPHY_EDGE_ROW_18_Right_18 VGND VGND VPWR VPWR sky130_fd_sc_hd__decap_3
Xinput3 ALU_control[2] VGND VGND VPWR VPWR net3 sky130_fd_sc_hd__clkbuf_2
X_761_ _362_ _324_ _321_ _318_ VGND VGND VPWR VPWR _325_ sky130_fd_sc_hd__o211a_1
XFILLER_21_78 VGND VGND VPWR VPWR sky130_fd_sc_hd__fill_1
XTAP_TAPCELL_ROW_17_118 VGND VPWR sky130_fd_sc_hd__tapvpwrvgnd_1
X_692_ net62 net64 net66 net20 net83 net77 VGND VGND VPWR VPWR _259_ sky130_fd_sc_hd__mux4_1
XFILLER_15_123 VGND VGND VPWR VPWR sky130_fd_sc_hd__decap_8
XFILLER_7_36 VPWR VGND VPWR VGND sky130_ef_sc_hd__decap_12
XTAP_TAPCELL_ROW_31_165 VGND VPWR sky130_fd_sc_hd__tapvpwrvgnd_1
XFILLER_21_148 VGND VGND VPWR VPWR sky130_fd_sc_hd__decap_8
XTAP_TAPCELL_ROW_7_90 VGND VPWR sky130_fd_sc_hd__tapvpwrvgnd_1
X_744_ _370_ _296_ _297_ _308_ VGND VGND VPWR VPWR net42 sky130_fd_sc_hd__a31o_1
X_675_ _360_ _241_ VGND VGND VPWR VPWR _243_ sky130_fd_sc_hd__nor2_1
XFILLER_12_104 VGND VGND VPWR VPWR sky130_fd_sc_hd__fill_1
XPHY_EDGE_ROW_0_Right_0 VGND VGND VPWR VPWR sky130_fd_sc_hd__decap_3
XFILLER_11_181 VGND VGND VPWR VPWR sky130_fd_sc_hd__decap_8
X_391_ net68 net71 VGND VGND VPWR VPWR _346_ sky130_fd_sc_hd__or2_2
X_460_ net105 _340_ VGND VGND VPWR VPWR _037_ sky130_fd_sc_hd__or2_1
X_727_ _338_ _290_ VGND VGND VPWR VPWR _292_ sky130_fd_sc_hd__or2_1
X_658_ net6 _200_ VGND VGND VPWR VPWR _227_ sky130_fd_sc_hd__and2_1
X_589_ net90 net34 net55 _160_ VGND VGND VPWR VPWR _161_ sky130_fd_sc_hd__o211a_1
XFILLER_4_15 VGND VGND VPWR VPWR sky130_fd_sc_hd__decap_4
XTAP_TAPCELL_ROW_4_80 VGND VPWR sky130_fd_sc_hd__tapvpwrvgnd_1
XFILLER_4_122 VGND VGND VPWR VPWR sky130_fd_sc_hd__fill_2
Xfanout69 net70 VGND VGND VPWR VPWR net69 sky130_fd_sc_hd__buf_1
XFILLER_13_57 VGND VGND VPWR VPWR sky130_fd_sc_hd__decap_3
XFILLER_1_158 VGND VGND VPWR VPWR sky130_fd_sc_hd__decap_8
XFILLER_1_169 VPWR VGND VPWR VGND sky130_ef_sc_hd__decap_12
X_512_ net15 net14 net98 net100 net82 net76 VGND VGND VPWR VPWR _087_ sky130_fd_sc_hd__mux4_1
X_443_ _001_ _002_ _020_ _340_ VGND VGND VPWR VPWR _021_ sky130_fd_sc_hd__o22a_1
XFILLER_1_27 VGND VGND VPWR VPWR sky130_fd_sc_hd__decap_4
Xinput4 ALU_control[3] VGND VGND VPWR VPWR net4 sky130_fd_sc_hd__clkbuf_2
XTAP_TAPCELL_ROW_1_70 VGND VPWR sky130_fd_sc_hd__tapvpwrvgnd_1
X_426_ net71 net75 _003_ VGND VGND VPWR VPWR _004_ sky130_fd_sc_hd__or3_1
X_409_ net85 net79 VGND VGND VPWR VPWR _364_ sky130_fd_sc_hd__nor2_1
XFILLER_21_57 VGND VGND VPWR VPWR sky130_fd_sc_hd__decap_8
XFILLER_30_138 VGND VGND VPWR VPWR sky130_fd_sc_hd__fill_2
XFILLER_30_7 VPWR VGND VPWR VGND sky130_ef_sc_hd__decap_12
X_691_ _257_ _371_ _256_ VGND VGND VPWR VPWR _258_ sky130_fd_sc_hd__or3b_1
X_760_ net69 _165_ _323_ VGND VGND VPWR VPWR _324_ sky130_fd_sc_hd__a21oi_1
XTAP_TAPCELL_ROW_17_119 VGND VPWR sky130_fd_sc_hd__tapvpwrvgnd_1
XFILLER_15_157 VGND VGND VPWR VPWR sky130_fd_sc_hd__decap_4
XFILLER_15_135 VPWR VGND VPWR VGND sky130_ef_sc_hd__decap_12
XFILLER_7_48 VGND VGND VPWR VPWR sky130_fd_sc_hd__decap_8
X_674_ net64 net23 net55 _241_ VGND VGND VPWR VPWR _242_ sky130_fd_sc_hd__o211a_1
XTAP_TAPCELL_ROW_22_133 VGND VPWR sky130_fd_sc_hd__tapvpwrvgnd_1
X_743_ _299_ _305_ _306_ _307_ VGND VGND VPWR VPWR _308_ sky130_fd_sc_hd__or4_1
XFILLER_20_171 VPWR VGND VPWR VGND sky130_ef_sc_hd__decap_12
XFILLER_16_13 VGND VGND VPWR VPWR sky130_fd_sc_hd__fill_1
XFILLER_12_127 VPWR VGND VPWR VGND sky130_ef_sc_hd__decap_12
X_390_ net67 net73 VGND VGND VPWR VPWR _345_ sky130_fd_sc_hd__nor2_2
X_726_ _338_ _290_ VGND VGND VPWR VPWR _291_ sky130_fd_sc_hd__nand2_1
X_657_ _186_ _219_ _225_ VGND VGND VPWR VPWR _226_ sky130_fd_sc_hd__a21oi_1
X_588_ net105 net90 net34 VGND VGND VPWR VPWR _160_ sky130_fd_sc_hd__nand3b_1
XFILLER_4_167 VPWR VGND VPWR VGND sky130_ef_sc_hd__decap_12
XTAP_TAPCELL_ROW_4_81 VGND VPWR sky130_fd_sc_hd__tapvpwrvgnd_1
X_511_ _057_ _084_ _083_ VGND VGND VPWR VPWR _086_ sky130_fd_sc_hd__o21ai_1
X_442_ net67 _016_ _019_ VGND VGND VPWR VPWR _020_ sky130_fd_sc_hd__a21oi_1
X_709_ _273_ _274_ VGND VGND VPWR VPWR _275_ sky130_fd_sc_hd__or2_1
XFILLER_0_181 VGND VGND VPWR VPWR sky130_fd_sc_hd__decap_8
XTAP_TAPCELL_ROW_1_71 VGND VPWR sky130_fd_sc_hd__tapvpwrvgnd_1
Xinput5 SrcA[0] VGND VGND VPWR VPWR net5 sky130_fd_sc_hd__buf_2
X_425_ _333_ net81 _354_ VGND VGND VPWR VPWR _003_ sky130_fd_sc_hd__o21a_1
XFILLER_19_57 VGND VGND VPWR VPWR sky130_fd_sc_hd__decap_8
XFILLER_10_26 VGND VGND VPWR VPWR sky130_fd_sc_hd__fill_2
XPHY_EDGE_ROW_27_Left_59 VGND VGND VPWR VPWR sky130_fd_sc_hd__decap_3
XFILLER_18_100 VGND VGND VPWR VPWR sky130_fd_sc_hd__fill_1
X_408_ net67 _362_ VGND VGND VPWR VPWR _363_ sky130_fd_sc_hd__nor2_1
X_690_ _247_ _249_ _255_ VGND VGND VPWR VPWR _257_ sky130_fd_sc_hd__and3_1
XTAP_TAPCELL_ROW_25_142 VGND VPWR sky130_fd_sc_hd__tapvpwrvgnd_1
XFILLER_15_169 VGND VGND VPWR VPWR sky130_fd_sc_hd__decap_6
XFILLER_15_147 VGND VGND VPWR VPWR sky130_fd_sc_hd__decap_6
Xinput30 SrcB[3] VGND VGND VPWR VPWR net30 sky130_fd_sc_hd__clkbuf_1
XTAP_TAPCELL_ROW_22_134 VGND VPWR sky130_fd_sc_hd__tapvpwrvgnd_1
XFILLER_20_183 VGND VGND VPWR VPWR sky130_fd_sc_hd__decap_4
XFILLER_12_139 VGND VGND VPWR VPWR sky130_fd_sc_hd__fill_1
X_673_ net105 _337_ net23 VGND VGND VPWR VPWR _241_ sky130_fd_sc_hd__or3b_1
X_742_ net69 _137_ VGND VGND VPWR VPWR _307_ sky130_fd_sc_hd__and2_1
XFILLER_11_150 VGND VGND VPWR VPWR sky130_fd_sc_hd__decap_3
XFILLER_27_68 VGND VGND VPWR VPWR sky130_fd_sc_hd__fill_1
XFILLER_27_57 VGND VGND VPWR VPWR sky130_fd_sc_hd__decap_4
XPHY_EDGE_ROW_14_Left_46 VGND VGND VPWR VPWR sky130_fd_sc_hd__decap_3
X_725_ net26 _289_ VGND VGND VPWR VPWR _290_ sky130_fd_sc_hd__xor2_1
X_656_ net6 net22 _368_ _162_ _224_ VGND VGND VPWR VPWR _225_ sky130_fd_sc_hd__a311o_1
X_587_ net90 _149_ VGND VGND VPWR VPWR _159_ sky130_fd_sc_hd__nor2_1
XFILLER_4_179 VGND VGND VPWR VPWR sky130_fd_sc_hd__decap_8
XFILLER_13_15 VGND VGND VPWR VPWR sky130_fd_sc_hd__decap_8
X_510_ _057_ _083_ _084_ VGND VGND VPWR VPWR _085_ sky130_fd_sc_hd__or3_2
X_441_ _348_ _017_ _018_ _345_ VGND VGND VPWR VPWR _019_ sky130_fd_sc_hd__a22o_1
X_708_ net60 _272_ VGND VGND VPWR VPWR _274_ sky130_fd_sc_hd__nor2_1
X_639_ _371_ _197_ _198_ _208_ VGND VGND VPWR VPWR net52 sky130_fd_sc_hd__o31ai_1
XFILLER_5_82 VGND VGND VPWR VPWR sky130_fd_sc_hd__decap_6
XTAP_TAPCELL_ROW_1_72 VGND VPWR sky130_fd_sc_hd__tapvpwrvgnd_1
X_424_ _357_ _375_ _000_ _371_ VGND VGND VPWR VPWR _002_ sky130_fd_sc_hd__a31o_1
Xinput6 SrcA[10] VGND VGND VPWR VPWR net6 sky130_fd_sc_hd__buf_1
XFILLER_27_101 VGND VGND VPWR VPWR sky130_fd_sc_hd__decap_8
XFILLER_27_189 VGND VGND VPWR VPWR sky130_fd_sc_hd__fill_1
XFILLER_27_167 VGND VGND VPWR VPWR sky130_fd_sc_hd__fill_1
XFILLER_27_145 VGND VGND VPWR VPWR sky130_fd_sc_hd__fill_2
XPHY_EDGE_ROW_23_Right_23 VGND VGND VPWR VPWR sky130_fd_sc_hd__decap_3
XPHY_EDGE_ROW_14_Right_14 VGND VGND VPWR VPWR sky130_fd_sc_hd__decap_3
XPHY_EDGE_ROW_2_Left_34 VGND VGND VPWR VPWR sky130_fd_sc_hd__decap_3
XTAP_TAPCELL_ROW_28_151 VGND VPWR sky130_fd_sc_hd__tapvpwrvgnd_1
XFILLER_24_115 VGND VGND VPWR VPWR sky130_fd_sc_hd__fill_2
XFILLER_18_189 VGND VGND VPWR VPWR sky130_fd_sc_hd__fill_1
XFILLER_18_178 VGND VGND VPWR VPWR sky130_fd_sc_hd__fill_2
X_407_ net104 _359_ VGND VGND VPWR VPWR _362_ sky130_fd_sc_hd__nand2_2
XFILLER_2_83 VGND VGND VPWR VPWR sky130_fd_sc_hd__fill_1
XTAP_TAPCELL_ROW_25_143 VGND VPWR sky130_fd_sc_hd__tapvpwrvgnd_1
XFILLER_23_181 VGND VGND VPWR VPWR sky130_fd_sc_hd__decap_8
XFILLER_21_26 VGND VGND VPWR VPWR sky130_fd_sc_hd__decap_4
XFILLER_21_129 VGND VGND VPWR VPWR sky130_fd_sc_hd__fill_1
XFILLER_21_107 VGND VGND VPWR VPWR sky130_fd_sc_hd__decap_4
Xinput20 SrcA[9] VGND VGND VPWR VPWR net20 sky130_fd_sc_hd__buf_1
XFILLER_16_7 VGND VGND VPWR VPWR sky130_fd_sc_hd__decap_6
Xinput31 SrcB[4] VGND VGND VPWR VPWR net31 sky130_fd_sc_hd__clkbuf_2
XTAP_TAPCELL_ROW_22_135 VGND VPWR sky130_fd_sc_hd__tapvpwrvgnd_1
X_672_ _346_ _239_ _238_ _361_ VGND VGND VPWR VPWR _240_ sky130_fd_sc_hd__o211a_1
X_741_ net69 _142_ _301_ _345_ VGND VGND VPWR VPWR _306_ sky130_fd_sc_hd__a2bb2o_1
XFILLER_7_166 VGND VGND VPWR VPWR sky130_fd_sc_hd__fill_2
XPHY_EDGE_ROW_4_Right_4 VGND VGND VPWR VPWR sky130_fd_sc_hd__decap_3
XFILLER_8_93 VPWR VGND VPWR VGND sky130_ef_sc_hd__decap_12
XPHY_EDGE_ROW_31_Left_63 VGND VGND VPWR VPWR sky130_fd_sc_hd__decap_3
X_724_ net25 _251_ net56 VGND VGND VPWR VPWR _289_ sky130_fd_sc_hd__o21a_1
X_655_ net66 net22 net55 _223_ VGND VGND VPWR VPWR _224_ sky130_fd_sc_hd__o211a_1
X_586_ net95 net92 net90 _099_ VGND VGND VPWR VPWR _158_ sky130_fd_sc_hd__and4_1
X_440_ net100 net98 net97 net96 net82 net76 VGND VGND VPWR VPWR _018_ sky130_fd_sc_hd__mux4_1
X_707_ net60 _272_ VGND VGND VPWR VPWR _273_ sky130_fd_sc_hd__and2_1
X_638_ _367_ _199_ _200_ _207_ VGND VGND VPWR VPWR _208_ sky130_fd_sc_hd__o31a_1
X_569_ _140_ _141_ _049_ VGND VGND VPWR VPWR _142_ sky130_fd_sc_hd__a21bo_1
XFILLER_24_37 VPWR VGND VPWR VGND sky130_ef_sc_hd__decap_12
XFILLER_24_26 VGND VGND VPWR VPWR sky130_fd_sc_hd__fill_2
XFILLER_14_92 VGND VGND VPWR VPWR sky130_fd_sc_hd__fill_1
X_423_ _375_ _000_ _357_ VGND VGND VPWR VPWR _001_ sky130_fd_sc_hd__a21oi_1
Xinput7 SrcA[11] VGND VGND VPWR VPWR net7 sky130_fd_sc_hd__buf_1
XFILLER_27_113 VPWR VGND VPWR VGND sky130_ef_sc_hd__decap_12
XFILLER_19_26 VGND VGND VPWR VPWR sky130_fd_sc_hd__fill_2
XFILLER_4_3 VPWR VGND VPWR VGND sky130_ef_sc_hd__decap_12
XTAP_TAPCELL_ROW_28_152 VGND VPWR sky130_fd_sc_hd__tapvpwrvgnd_1
X_406_ net104 _359_ VGND VGND VPWR VPWR _361_ sky130_fd_sc_hd__and2_2
Xmax_cap58 _366_ VGND VGND VPWR VPWR net58 sky130_fd_sc_hd__clkbuf_2
XTAP_TAPCELL_ROW_25_144 VGND VPWR sky130_fd_sc_hd__tapvpwrvgnd_1
XFILLER_11_60 VPWR VGND VPWR VGND sky130_ef_sc_hd__decap_12
Xinput10 SrcA[14] VGND VGND VPWR VPWR net10 sky130_fd_sc_hd__buf_1
XFILLER_20_141 VGND VGND VPWR VPWR sky130_fd_sc_hd__decap_4
XFILLER_16_27 VGND VGND VPWR VPWR sky130_fd_sc_hd__fill_1
Xinput32 SrcB[5] VGND VGND VPWR VPWR net32 sky130_fd_sc_hd__clkbuf_2
Xinput21 SrcB[0] VGND VGND VPWR VPWR net21 sky130_fd_sc_hd__clkbuf_1
X_740_ _348_ _361_ _221_ _304_ VGND VGND VPWR VPWR _305_ sky130_fd_sc_hd__a31o_1
X_671_ net64 net66 net20 net19 net83 net77 VGND VGND VPWR VPWR _239_ sky130_fd_sc_hd__mux4_1
XFILLER_7_123 VGND VGND VPWR VPWR sky130_fd_sc_hd__decap_6
XFILLER_7_145 VGND VGND VPWR VPWR sky130_fd_sc_hd__fill_1
XFILLER_21_6 VPWR VGND VPWR VGND sky130_ef_sc_hd__decap_12
XFILLER_4_19 VGND VGND VPWR VPWR sky130_fd_sc_hd__fill_1
X_723_ _276_ _277_ _288_ VGND VGND VPWR VPWR net41 sky130_fd_sc_hd__o21ai_1
X_654_ net105 _336_ net22 VGND VGND VPWR VPWR _223_ sky130_fd_sc_hd__or3b_1
X_585_ _348_ _060_ _074_ _345_ _156_ VGND VGND VPWR VPWR _157_ sky130_fd_sc_hd__a221o_1
XFILLER_3_181 VGND VGND VPWR VPWR sky130_fd_sc_hd__decap_8
XFILLER_28_91 VGND VGND VPWR VPWR sky130_fd_sc_hd__fill_1
X_706_ net25 _271_ VGND VGND VPWR VPWR _272_ sky130_fd_sc_hd__xor2_1
X_637_ _016_ _186_ _203_ _206_ VGND VGND VPWR VPWR _207_ sky130_fd_sc_hd__a211oi_1
XFILLER_24_49 VGND VGND VPWR VPWR sky130_fd_sc_hd__decap_4
X_568_ net73 net80 net102 VGND VGND VPWR VPWR _141_ sky130_fd_sc_hd__o21ai_1
X_499_ net97 net96 net95 net93 net81 net75 VGND VGND VPWR VPWR _075_ sky130_fd_sc_hd__mux4_1
X_422_ _373_ _374_ net12 VGND VGND VPWR VPWR _000_ sky130_fd_sc_hd__o21ai_1
Xinput8 SrcA[12] VGND VGND VPWR VPWR net8 sky130_fd_sc_hd__clkbuf_1
XFILLER_27_169 VPWR VGND VPWR VGND sky130_ef_sc_hd__decap_12
XFILLER_27_125 VPWR VGND VPWR VGND sky130_ef_sc_hd__decap_12
XFILLER_10_29 VGND VGND VPWR VPWR sky130_fd_sc_hd__fill_2
XTAP_TAPCELL_ROW_28_153 VGND VPWR sky130_fd_sc_hd__tapvpwrvgnd_1
XFILLER_18_158 VGND VGND VPWR VPWR sky130_fd_sc_hd__decap_6
XFILLER_18_125 VPWR VGND VPWR VGND sky130_ef_sc_hd__decap_12
X_405_ net88 net4 net3 VGND VGND VPWR VPWR _360_ sky130_fd_sc_hd__or3b_4
XFILLER_24_139 VGND VGND VPWR VPWR sky130_fd_sc_hd__fill_1
XFILLER_30_109 VGND VGND VPWR VPWR sky130_fd_sc_hd__decap_8
XFILLER_11_94 VGND VGND VPWR VPWR sky130_fd_sc_hd__fill_1
XFILLER_11_72 VGND VGND VPWR VPWR sky130_fd_sc_hd__fill_1
Xmax_cap59 _365_ VGND VGND VPWR VPWR net59 sky130_fd_sc_hd__buf_1
Xinput22 SrcB[10] VGND VGND VPWR VPWR net22 sky130_fd_sc_hd__dlymetal6s2s_1
Xinput33 SrcB[6] VGND VGND VPWR VPWR net33 sky130_fd_sc_hd__buf_1
XFILLER_14_183 VGND VGND VPWR VPWR sky130_fd_sc_hd__decap_6
Xinput11 SrcA[15] VGND VGND VPWR VPWR net11 sky130_fd_sc_hd__clkbuf_1
XFILLER_20_131 VGND VGND VPWR VPWR sky130_fd_sc_hd__decap_8
X_670_ _332_ _164_ _066_ _345_ VGND VGND VPWR VPWR _238_ sky130_fd_sc_hd__a211o_1
XFILLER_22_93 VGND VGND VPWR VPWR sky130_fd_sc_hd__decap_3
XFILLER_7_113 VGND VGND VPWR VPWR sky130_fd_sc_hd__fill_2
XFILLER_27_38 VPWR VGND VPWR VGND sky130_ef_sc_hd__decap_12
X_722_ _278_ _279_ _283_ _287_ VGND VGND VPWR VPWR _288_ sky130_fd_sc_hd__o211a_1
X_653_ _346_ _221_ _220_ _361_ VGND VGND VPWR VPWR _222_ sky130_fd_sc_hd__o211ai_1
XFILLER_17_60 VGND VGND VPWR VPWR sky130_fd_sc_hd__decap_6
X_584_ net106 net70 net101 net59 VGND VGND VPWR VPWR _156_ sky130_fd_sc_hd__and4b_1
XFILLER_28_81 VGND VGND VPWR VPWR sky130_fd_sc_hd__decap_3
X_705_ net56 _251_ VGND VGND VPWR VPWR _271_ sky130_fd_sc_hd__nand2_1
X_636_ _346_ _204_ _205_ VGND VGND VPWR VPWR _206_ sky130_fd_sc_hd__o21ba_1
X_498_ net91 net89 net87 net66 net83 net77 VGND VGND VPWR VPWR _074_ sky130_fd_sc_hd__mux4_1
X_567_ net72 net80 _342_ VGND VGND VPWR VPWR _140_ sky130_fd_sc_hd__or3b_1
X_421_ net100 _373_ _374_ VGND VGND VPWR VPWR _375_ sky130_fd_sc_hd__or3_1
Xinput9 SrcA[13] VGND VGND VPWR VPWR net9 sky130_fd_sc_hd__clkbuf_1
X_619_ _361_ _185_ _186_ _344_ VGND VGND VPWR VPWR _190_ sky130_fd_sc_hd__a22o_1
XFILLER_27_137 VGND VGND VPWR VPWR sky130_fd_sc_hd__decap_8
XFILLER_10_19 VGND VGND VPWR VPWR sky130_fd_sc_hd__fill_1
XFILLER_18_137 VGND VGND VPWR VPWR sky130_fd_sc_hd__decap_3
X_404_ net2 net4 net3 VGND VGND VPWR VPWR _359_ sky130_fd_sc_hd__nor3b_1
XPHY_EDGE_ROW_10_Right_10 VGND VGND VPWR VPWR sky130_fd_sc_hd__decap_3
XFILLER_2_75 VGND VGND VPWR VPWR sky130_fd_sc_hd__fill_1
XFILLER_23_140 VGND VGND VPWR VPWR sky130_fd_sc_hd__fill_1
XPHY_EDGE_ROW_6_Left_38 VGND VGND VPWR VPWR sky130_fd_sc_hd__decap_3
Xinput23 SrcB[11] VGND VGND VPWR VPWR net23 sky130_fd_sc_hd__dlymetal6s2s_1
Xinput34 SrcB[7] VGND VGND VPWR VPWR net34 sky130_fd_sc_hd__dlymetal6s2s_1
Xinput12 SrcA[1] VGND VGND VPWR VPWR net12 sky130_fd_sc_hd__buf_1
XFILLER_16_29 VGND VGND VPWR VPWR sky130_fd_sc_hd__decap_8
XFILLER_11_143 VGND VGND VPWR VPWR sky130_fd_sc_hd__fill_1
XFILLER_11_121 VGND VGND VPWR VPWR sky130_fd_sc_hd__decap_3
XFILLER_8_41 VGND VGND VPWR VPWR sky130_fd_sc_hd__fill_1
XFILLER_8_74 VGND VGND VPWR VPWR sky130_fd_sc_hd__decap_3
X_721_ net69 _118_ _286_ VGND VGND VPWR VPWR _287_ sky130_fd_sc_hd__o21ba_1
X_652_ net66 net87 net19 net91 net83 net77 VGND VGND VPWR VPWR _221_ sky130_fd_sc_hd__mux4_1
X_583_ _129_ _132_ _153_ VGND VGND VPWR VPWR _155_ sky130_fd_sc_hd__a21o_1
XPHY_EDGE_ROW_9_Left_41 VGND VGND VPWR VPWR sky130_fd_sc_hd__decap_3
XPHY_EDGE_ROW_8_Right_8 VGND VGND VPWR VPWR sky130_fd_sc_hd__decap_3
X_704_ _258_ _270_ VGND VGND VPWR VPWR net40 sky130_fd_sc_hd__nand2_1
X_566_ _339_ _138_ _137_ VGND VGND VPWR VPWR _139_ sky130_fd_sc_hd__a21oi_1
XFILLER_0_153 VPWR VGND VPWR VGND sky130_ef_sc_hd__decap_12
X_635_ net67 _004_ _111_ net71 _362_ VGND VGND VPWR VPWR _205_ sky130_fd_sc_hd__a221o_1
X_497_ _363_ _066_ _068_ _072_ VGND VGND VPWR VPWR _073_ sky130_fd_sc_hd__a211o_1
XFILLER_24_29 VGND VGND VPWR VPWR sky130_fd_sc_hd__decap_4
XFILLER_24_18 VGND VGND VPWR VPWR sky130_fd_sc_hd__decap_8
XFILLER_30_83 VGND VGND VPWR VPWR sky130_fd_sc_hd__fill_1
X_420_ net85 net57 net79 VGND VGND VPWR VPWR _374_ sky130_fd_sc_hd__a21oi_1
X_618_ _360_ _187_ VGND VGND VPWR VPWR _189_ sky130_fd_sc_hd__nor2_1
X_549_ net94 _099_ VGND VGND VPWR VPWR _123_ sky130_fd_sc_hd__nand2_1
XFILLER_25_50 VGND VGND VPWR VPWR sky130_fd_sc_hd__decap_6
X_403_ net5 net81 _355_ _356_ VGND VGND VPWR VPWR _358_ sky130_fd_sc_hd__o211a_1
XPHY_EDGE_ROW_22_Left_54 VGND VGND VPWR VPWR sky130_fd_sc_hd__decap_3
XFILLER_23_130 VGND VGND VPWR VPWR sky130_fd_sc_hd__fill_2
XFILLER_11_30 VPWR VGND VPWR VGND sky130_ef_sc_hd__decap_12
Xinput24 SrcB[12] VGND VGND VPWR VPWR net24 sky130_fd_sc_hd__dlymetal6s2s_1
Xinput35 SrcB[8] VGND VGND VPWR VPWR net35 sky130_fd_sc_hd__clkbuf_2
XFILLER_2_3 VPWR VGND VPWR VGND sky130_ef_sc_hd__decap_12
Xinput13 SrcA[2] VGND VGND VPWR VPWR net13 sky130_fd_sc_hd__buf_1
XTAP_TAPCELL_ROW_13_106 VGND VPWR sky130_fd_sc_hd__tapvpwrvgnd_1
XFILLER_11_166 VGND VGND VPWR VPWR sky130_fd_sc_hd__fill_2
XFILLER_7_104 VGND VGND VPWR VPWR sky130_fd_sc_hd__decap_8
X_720_ net61 net25 _368_ _162_ _285_ VGND VGND VPWR VPWR _286_ sky130_fd_sc_hd__a311o_1
X_582_ _129_ _132_ _153_ VGND VGND VPWR VPWR _154_ sky130_fd_sc_hd__nand3_1
X_651_ _332_ _135_ _041_ _345_ VGND VGND VPWR VPWR _220_ sky130_fd_sc_hd__a211o_1
XFILLER_28_50 VGND VGND VPWR VPWR sky130_fd_sc_hd__decap_4
X_703_ _266_ _269_ _262_ _263_ VGND VGND VPWR VPWR _270_ sky130_fd_sc_hd__and4bb_1
X_634_ net87 net19 net91 net93 net83 net77 VGND VGND VPWR VPWR _204_ sky130_fd_sc_hd__mux4_1
X_565_ _349_ _030_ _033_ _346_ VGND VGND VPWR VPWR _138_ sky130_fd_sc_hd__o22a_1
XFILLER_0_165 VGND VGND VPWR VPWR sky130_fd_sc_hd__decap_3
XFILLER_0_132 VGND VGND VPWR VPWR sky130_fd_sc_hd__fill_2
X_496_ _360_ _067_ _071_ VGND VGND VPWR VPWR _072_ sky130_fd_sc_hd__o21ai_1
XFILLER_30_40 VGND VGND VPWR VPWR sky130_fd_sc_hd__decap_6
X_617_ net89 net35 net55 _187_ VGND VGND VPWR VPWR _188_ sky130_fd_sc_hd__o211a_1
X_548_ net94 net32 net54 _121_ VGND VGND VPWR VPWR _122_ sky130_fd_sc_hd__o211a_1
X_479_ net14 _054_ VGND VGND VPWR VPWR _055_ sky130_fd_sc_hd__and2_1
XFILLER_25_73 VGND VGND VPWR VPWR sky130_fd_sc_hd__fill_1
X_402_ _331_ net85 VGND VGND VPWR VPWR _357_ sky130_fd_sc_hd__nand2_1
Xinput36 SrcB[9] VGND VGND VPWR VPWR net36 sky130_fd_sc_hd__clkbuf_2
Xinput25 SrcB[13] VGND VGND VPWR VPWR net25 sky130_fd_sc_hd__dlymetal6s2s_1
XTAP_TAPCELL_ROW_16_115 VGND VPWR sky130_fd_sc_hd__tapvpwrvgnd_1
XFILLER_11_42 VPWR VGND VPWR VGND sky130_ef_sc_hd__decap_12
Xinput14 SrcA[3] VGND VGND VPWR VPWR net14 sky130_fd_sc_hd__buf_1
XFILLER_28_3 VPWR VGND VPWR VGND sky130_ef_sc_hd__decap_12
XFILLER_22_85 VGND VGND VPWR VPWR sky130_fd_sc_hd__decap_8
XTAP_TAPCELL_ROW_13_107 VGND VPWR sky130_fd_sc_hd__tapvpwrvgnd_1
XFILLER_11_189 VGND VGND VPWR VPWR sky130_fd_sc_hd__fill_1
X_650_ net105 net80 _050_ _031_ VGND VGND VPWR VPWR _219_ sky130_fd_sc_hd__a31o_1
X_581_ net90 _152_ VGND VGND VPWR VPWR _153_ sky130_fd_sc_hd__xnor2_1
X_702_ _268_ net58 _267_ VGND VGND VPWR VPWR _269_ sky130_fd_sc_hd__and3b_1
X_633_ net87 net36 _368_ _162_ _202_ VGND VGND VPWR VPWR _203_ sky130_fd_sc_hd__a311o_1
X_564_ net73 _135_ _136_ _361_ VGND VGND VPWR VPWR _137_ sky130_fd_sc_hd__o211a_1
XFILLER_0_111 VGND VGND VPWR VPWR sky130_fd_sc_hd__fill_1
X_495_ _367_ _069_ _070_ VGND VGND VPWR VPWR _071_ sky130_fd_sc_hd__or3_1
XFILLER_5_55 VGND VGND VPWR VPWR sky130_fd_sc_hd__fill_1
XFILLER_30_85 VGND VGND VPWR VPWR sky130_fd_sc_hd__fill_2
XFILLER_29_181 VGND VGND VPWR VPWR sky130_fd_sc_hd__decap_8
X_616_ net105 _334_ net35 VGND VGND VPWR VPWR _187_ sky130_fd_sc_hd__or3b_1
X_547_ net104 net94 net32 VGND VGND VPWR VPWR _121_ sky130_fd_sc_hd__nand3b_1
X_478_ net67 _053_ VGND VGND VPWR VPWR _054_ sky130_fd_sc_hd__xnor2_1
XFILLER_26_162 VPWR VGND VPWR VGND sky130_ef_sc_hd__decap_12
XFILLER_25_96 VGND VGND VPWR VPWR sky130_fd_sc_hd__fill_1
X_401_ net3 net4 VGND VGND VPWR VPWR _356_ sky130_fd_sc_hd__nor2_1
XTAP_TAPCELL_ROW_19_124 VGND VPWR sky130_fd_sc_hd__tapvpwrvgnd_1
XFILLER_17_184 VGND VGND VPWR VPWR sky130_fd_sc_hd__fill_1
XFILLER_23_165 VGND VGND VPWR VPWR sky130_fd_sc_hd__decap_3
XTAP_TAPCELL_ROW_16_116 VGND VPWR sky130_fd_sc_hd__tapvpwrvgnd_1
XFILLER_11_54 VGND VGND VPWR VPWR sky130_fd_sc_hd__fill_2
XTAP_TAPCELL_ROW_7_88 VGND VPWR sky130_fd_sc_hd__tapvpwrvgnd_1
Xinput26 SrcB[14] VGND VGND VPWR VPWR net26 sky130_fd_sc_hd__dlymetal6s2s_1
Xinput15 SrcA[4] VGND VGND VPWR VPWR net15 sky130_fd_sc_hd__buf_1
XTAP_TAPCELL_ROW_21_130 VGND VPWR sky130_fd_sc_hd__tapvpwrvgnd_1
XTAP_TAPCELL_ROW_13_108 VGND VPWR sky130_fd_sc_hd__tapvpwrvgnd_1
XFILLER_11_113 VGND VGND VPWR VPWR sky130_fd_sc_hd__decap_8
X_580_ net34 _151_ VGND VGND VPWR VPWR _152_ sky130_fd_sc_hd__xnor2_1
XFILLER_3_131 VGND VGND VPWR VPWR sky130_fd_sc_hd__fill_2
XFILLER_28_85 VGND VGND VPWR VPWR sky130_fd_sc_hd__decap_6
XPHY_EDGE_ROW_26_Right_26 VGND VGND VPWR VPWR sky130_fd_sc_hd__decap_3
X_701_ net64 net63 _227_ VGND VGND VPWR VPWR _268_ sky130_fd_sc_hd__and3_1
X_632_ net87 net36 net55 _201_ VGND VGND VPWR VPWR _202_ sky130_fd_sc_hd__o211a_1
XPHY_EDGE_ROW_17_Right_17 VGND VGND VPWR VPWR sky130_fd_sc_hd__decap_3
XFILLER_0_189 VGND VGND VPWR VPWR sky130_fd_sc_hd__fill_1
XFILLER_0_145 VGND VGND VPWR VPWR sky130_fd_sc_hd__decap_3
XFILLER_0_123 VGND VGND VPWR VPWR sky130_fd_sc_hd__decap_3
X_563_ net73 _040_ VGND VGND VPWR VPWR _136_ sky130_fd_sc_hd__nand2_1
X_494_ net100 net98 net97 VGND VGND VPWR VPWR _070_ sky130_fd_sc_hd__and3_1
XFILLER_30_53 VGND VGND VPWR VPWR sky130_fd_sc_hd__decap_3
X_546_ net68 _118_ _119_ _113_ _115_ VGND VGND VPWR VPWR _120_ sky130_fd_sc_hd__a32o_1
X_615_ net68 _340_ VGND VGND VPWR VPWR _186_ sky130_fd_sc_hd__nor2_1
X_477_ _365_ net57 VGND VGND VPWR VPWR _053_ sky130_fd_sc_hd__and2b_1
XFILLER_26_174 VGND VGND VPWR VPWR sky130_fd_sc_hd__decap_6
X_400_ net88 net104 _354_ VGND VGND VPWR VPWR _355_ sky130_fd_sc_hd__a21o_1
XTAP_TAPCELL_ROW_19_125 VGND VPWR sky130_fd_sc_hd__tapvpwrvgnd_1
XFILLER_2_68 VGND VGND VPWR VPWR sky130_fd_sc_hd__fill_1
X_529_ net32 _102_ VGND VGND VPWR VPWR _103_ sky130_fd_sc_hd__xnor2_1
XFILLER_23_111 VGND VGND VPWR VPWR sky130_fd_sc_hd__fill_1
XPHY_EDGE_ROW_26_Left_58 VGND VGND VPWR VPWR sky130_fd_sc_hd__decap_3
Xinput27 SrcB[15] VGND VGND VPWR VPWR net27 sky130_fd_sc_hd__buf_1
XTAP_TAPCELL_ROW_16_117 VGND VPWR sky130_fd_sc_hd__tapvpwrvgnd_1
XTAP_TAPCELL_ROW_7_89 VGND VPWR sky130_fd_sc_hd__tapvpwrvgnd_1
Xinput16 SrcA[5] VGND VGND VPWR VPWR net16 sky130_fd_sc_hd__clkbuf_1
XFILLER_9_181 VGND VGND VPWR VPWR sky130_fd_sc_hd__decap_8
XFILLER_22_10 VGND VGND VPWR VPWR sky130_fd_sc_hd__decap_3
XTAP_TAPCELL_ROW_21_131 VGND VPWR sky130_fd_sc_hd__tapvpwrvgnd_1
XFILLER_11_169 VPWR VGND VPWR VGND sky130_ef_sc_hd__decap_12
XFILLER_11_158 VGND VGND VPWR VPWR sky130_fd_sc_hd__decap_8
XFILLER_0_3 VPWR VGND VPWR VGND sky130_ef_sc_hd__decap_12
XFILLER_3_110 VGND VGND VPWR VPWR sky130_fd_sc_hd__fill_2
XFILLER_3_143 VGND VGND VPWR VPWR sky130_fd_sc_hd__fill_1
XFILLER_3_154 VPWR VGND VPWR VGND sky130_ef_sc_hd__decap_12
XTAP_TAPCELL_ROW_4_79 VGND VPWR sky130_fd_sc_hd__tapvpwrvgnd_1
XPHY_EDGE_ROW_29_Left_61 VGND VGND VPWR VPWR sky130_fd_sc_hd__decap_3
XPHY_EDGE_ROW_13_Left_45 VGND VGND VPWR VPWR sky130_fd_sc_hd__decap_3
X_700_ net6 net65 _200_ net63 VGND VGND VPWR VPWR _267_ sky130_fd_sc_hd__a31o_1
XFILLER_0_90 VGND VGND VPWR VPWR sky130_fd_sc_hd__decap_4
X_631_ net105 _335_ net36 VGND VGND VPWR VPWR _201_ sky130_fd_sc_hd__or3b_1
XFILLER_5_35 VPWR VGND VPWR VGND sky130_ef_sc_hd__decap_12
XFILLER_5_57 VGND VGND VPWR VPWR sky130_fd_sc_hd__fill_1
X_493_ net100 net98 net97 VGND VGND VPWR VPWR _069_ sky130_fd_sc_hd__a21oi_1
X_562_ net93 net94 net15 net97 net81 net75 VGND VGND VPWR VPWR _135_ sky130_fd_sc_hd__mux4_1
X_545_ net86 _012_ _037_ _117_ VGND VGND VPWR VPWR _119_ sky130_fd_sc_hd__a211o_1
X_614_ net5 net67 net59 _184_ VGND VGND VPWR VPWR _185_ sky130_fd_sc_hd__a31o_1
X_476_ _370_ _027_ _028_ _052_ VGND VGND VPWR VPWR net45 sky130_fd_sc_hd__a31o_1
XFILLER_27_109 VGND VGND VPWR VPWR sky130_fd_sc_hd__decap_3
XFILLER_26_153 VGND VGND VPWR VPWR sky130_fd_sc_hd__decap_3
XTAP_TAPCELL_ROW_19_126 VGND VPWR sky130_fd_sc_hd__tapvpwrvgnd_1
X_528_ net31 _078_ net57 VGND VGND VPWR VPWR _102_ sky130_fd_sc_hd__o21a_1
X_459_ net106 _340_ VGND VGND VPWR VPWR _036_ sky130_fd_sc_hd__nor2_1
XFILLER_23_189 VGND VGND VPWR VPWR sky130_fd_sc_hd__fill_1
XFILLER_11_12 VGND VGND VPWR VPWR sky130_fd_sc_hd__fill_1
XTAP_TAPCELL_ROW_24_140 VGND VPWR sky130_fd_sc_hd__tapvpwrvgnd_1
XFILLER_14_189 VGND VGND VPWR VPWR sky130_fd_sc_hd__fill_1
XFILLER_14_178 VGND VGND VPWR VPWR sky130_fd_sc_hd__fill_1
Xinput17 SrcA[6] VGND VGND VPWR VPWR net17 sky130_fd_sc_hd__clkbuf_1
XPHY_EDGE_ROW_1_Left_33 VGND VGND VPWR VPWR sky130_fd_sc_hd__decap_3
Xinput28 SrcB[1] VGND VGND VPWR VPWR net28 sky130_fd_sc_hd__clkbuf_1
XFILLER_20_159 VPWR VGND VPWR VGND sky130_ef_sc_hd__decap_12
XFILLER_22_99 VPWR VGND VPWR VGND sky130_ef_sc_hd__decap_12
XTAP_TAPCELL_ROW_21_132 VGND VPWR sky130_fd_sc_hd__tapvpwrvgnd_1
XFILLER_11_137 VGND VGND VPWR VPWR sky130_fd_sc_hd__decap_6
XFILLER_6_130 VGND VGND VPWR VPWR sky130_fd_sc_hd__fill_2
XFILLER_6_141 VPWR VGND VPWR VGND sky130_ef_sc_hd__decap_12
XFILLER_3_166 VGND VGND VPWR VPWR sky130_fd_sc_hd__fill_2
XPHY_EDGE_ROW_3_Right_3 VGND VGND VPWR VPWR sky130_fd_sc_hd__decap_3
XPHY_EDGE_ROW_30_Left_62 VGND VGND VPWR VPWR sky130_fd_sc_hd__decap_3
X_630_ net89 net87 _158_ VGND VGND VPWR VPWR _200_ sky130_fd_sc_hd__and3_1
X_561_ _370_ _132_ VGND VGND VPWR VPWR _134_ sky130_fd_sc_hd__nand2_1
XFILLER_0_169 VPWR VGND VPWR VGND sky130_ef_sc_hd__decap_12
XFILLER_5_47 VGND VGND VPWR VPWR sky130_fd_sc_hd__decap_8
X_492_ net67 net14 net54 _067_ VGND VGND VPWR VPWR _068_ sky130_fd_sc_hd__o211a_1
X_759_ _348_ _239_ _322_ _345_ VGND VGND VPWR VPWR _323_ sky130_fd_sc_hd__a22o_1
XFILLER_30_77 VGND VGND VPWR VPWR sky130_fd_sc_hd__decap_6
XFILLER_30_66 VGND VGND VPWR VPWR sky130_fd_sc_hd__fill_2
XFILLER_14_34 VGND VGND VPWR VPWR sky130_fd_sc_hd__fill_1
X_613_ _348_ _087_ _183_ _345_ VGND VGND VPWR VPWR _184_ sky130_fd_sc_hd__a22o_1
X_544_ _050_ _116_ _049_ VGND VGND VPWR VPWR _118_ sky130_fd_sc_hd__o21ai_1
X_475_ _049_ _051_ _048_ VGND VGND VPWR VPWR _052_ sky130_fd_sc_hd__a21o_1
XFILLER_25_88 VGND VGND VPWR VPWR sky130_fd_sc_hd__decap_8
X_389_ _341_ _343_ net71 VGND VGND VPWR VPWR _344_ sky130_fd_sc_hd__mux2_1
X_458_ net70 _031_ _034_ VGND VGND VPWR VPWR _035_ sky130_fd_sc_hd__a21o_1
XFILLER_2_48 VGND VGND VPWR VPWR sky130_fd_sc_hd__decap_3
XFILLER_2_15 VPWR VGND VPWR VGND sky130_ef_sc_hd__decap_12
X_527_ _370_ _085_ _086_ _101_ VGND VGND VPWR VPWR net47 sky130_fd_sc_hd__a31o_1
XFILLER_23_124 VGND VGND VPWR VPWR sky130_fd_sc_hd__fill_2
XTAP_TAPCELL_ROW_24_141 VGND VPWR sky130_fd_sc_hd__tapvpwrvgnd_1
Xinput18 SrcA[7] VGND VGND VPWR VPWR net18 sky130_fd_sc_hd__clkbuf_1
XFILLER_14_157 VGND VGND VPWR VPWR sky130_fd_sc_hd__fill_1
XFILLER_14_135 VGND VGND VPWR VPWR sky130_fd_sc_hd__decap_4
Xinput29 SrcB[2] VGND VGND VPWR VPWR net29 sky130_fd_sc_hd__clkbuf_1
XFILLER_6_164 VPWR VGND VPWR VGND sky130_ef_sc_hd__decap_12
XFILLER_17_34 VGND VGND VPWR VPWR sky130_fd_sc_hd__fill_1
XFILLER_17_12 VGND VGND VPWR VPWR sky130_fd_sc_hd__decap_3
XFILLER_3_189 VGND VGND VPWR VPWR sky130_fd_sc_hd__fill_1
XFILLER_28_99 VGND VGND VPWR VPWR sky130_fd_sc_hd__decap_4
X_560_ _085_ _105_ _130_ _131_ VGND VGND VPWR VPWR _133_ sky130_fd_sc_hd__o211a_1
XFILLER_5_15 VPWR VGND VPWR VGND sky130_ef_sc_hd__decap_12
X_491_ net104 _332_ net97 VGND VGND VPWR VPWR _067_ sky130_fd_sc_hd__or3b_1
X_689_ _247_ _249_ _255_ VGND VGND VPWR VPWR _256_ sky130_fd_sc_hd__a21o_1
XPHY_EDGE_ROW_22_Right_22 VGND VGND VPWR VPWR sky130_fd_sc_hd__decap_3
X_758_ net101 net103 net60 net62 net84 net80 VGND VGND VPWR VPWR _322_ sky130_fd_sc_hd__mux4_1
XPHY_EDGE_ROW_13_Right_13 VGND VGND VPWR VPWR sky130_fd_sc_hd__decap_3
XPHY_EDGE_ROW_31_Right_31 VGND VGND VPWR VPWR sky130_fd_sc_hd__decap_3
XFILLER_29_141 VGND VGND VPWR VPWR sky130_fd_sc_hd__fill_1
X_543_ _116_ VGND VGND VPWR VPWR _117_ sky130_fd_sc_hd__inv_2
X_612_ net89 net91 net93 net95 net83 net77 VGND VGND VPWR VPWR _183_ sky130_fd_sc_hd__mux4_1
X_474_ net70 net79 _050_ _035_ VGND VGND VPWR VPWR _051_ sky130_fd_sc_hd__a31o_1
XTAP_TAPCELL_ROW_27_150 VGND VPWR sky130_fd_sc_hd__tapvpwrvgnd_1
XFILLER_2_27 VGND VGND VPWR VPWR sky130_fd_sc_hd__fill_1
X_526_ _099_ _100_ _095_ _098_ VGND VGND VPWR VPWR _101_ sky130_fd_sc_hd__o211ai_1
XFILLER_23_169 VPWR VGND VPWR VGND sky130_ef_sc_hd__decap_12
X_388_ net62 net60 net103 net101 net85 net79 VGND VGND VPWR VPWR _343_ sky130_fd_sc_hd__mux4_1
X_457_ _345_ _032_ _033_ _348_ VGND VGND VPWR VPWR _034_ sky130_fd_sc_hd__a22o_1
Xinput19 SrcA[8] VGND VGND VPWR VPWR net19 sky130_fd_sc_hd__buf_1
XFILLER_20_139 VGND VGND VPWR VPWR sky130_fd_sc_hd__fill_1
X_509_ _022_ _026_ _055_ _025_ VGND VGND VPWR VPWR _084_ sky130_fd_sc_hd__a211oi_2
XFILLER_22_79 VGND VGND VPWR VPWR sky130_fd_sc_hd__fill_1
XFILLER_22_68 VGND VGND VPWR VPWR sky130_fd_sc_hd__decap_8
XFILLER_22_24 VGND VGND VPWR VPWR sky130_fd_sc_hd__fill_1
XFILLER_3_81 VGND VGND VPWR VPWR sky130_fd_sc_hd__fill_2
XFILLER_10_161 VPWR VGND VPWR VGND sky130_ef_sc_hd__decap_12
XFILLER_6_176 VPWR VGND VPWR VGND sky130_ef_sc_hd__decap_12
XFILLER_8_26 VGND VGND VPWR VPWR sky130_fd_sc_hd__fill_2
XTAP_TAPCELL_ROW_8_91 VGND VPWR sky130_fd_sc_hd__tapvpwrvgnd_1
XFILLER_31_3 VPWR VGND VPWR VGND sky130_ef_sc_hd__decap_12
X_490_ net71 _065_ VGND VGND VPWR VPWR _066_ sky130_fd_sc_hd__and2b_1
X_688_ _253_ _254_ VGND VGND VPWR VPWR _255_ sky130_fd_sc_hd__nand2_1
X_757_ net102 _319_ _320_ VGND VGND VPWR VPWR _321_ sky130_fd_sc_hd__a21oi_1
XPHY_EDGE_ROW_17_Left_49 VGND VGND VPWR VPWR sky130_fd_sc_hd__decap_3
XFILLER_5_27 VGND VGND VPWR VPWR sky130_fd_sc_hd__fill_2
XFILLER_14_47 VGND VGND VPWR VPWR sky130_fd_sc_hd__fill_1
X_611_ _171_ _174_ _180_ _371_ VGND VGND VPWR VPWR _182_ sky130_fd_sc_hd__a31oi_1
X_542_ net72 _015_ VGND VGND VPWR VPWR _116_ sky130_fd_sc_hd__and2b_1
X_473_ net72 net101 VGND VGND VPWR VPWR _050_ sky130_fd_sc_hd__and2_1
XFILLER_17_189 VGND VGND VPWR VPWR sky130_fd_sc_hd__fill_1
XFILLER_17_145 VPWR VGND VPWR VGND sky130_ef_sc_hd__decap_12
XFILLER_17_123 VGND VGND VPWR VPWR sky130_fd_sc_hd__fill_1
X_387_ net103 net101 net85 VGND VGND VPWR VPWR _342_ sky130_fd_sc_hd__mux2_1
X_456_ net93 net91 net89 net87 net83 net77 VGND VGND VPWR VPWR _033_ sky130_fd_sc_hd__mux4_1
X_525_ net96 _070_ _366_ VGND VGND VPWR VPWR _100_ sky130_fd_sc_hd__o21ai_1
XFILLER_31_181 VGND VGND VPWR VPWR sky130_fd_sc_hd__decap_8
XFILLER_14_115 VGND VGND VPWR VPWR sky130_fd_sc_hd__decap_4
XFILLER_22_181 VGND VGND VPWR VPWR sky130_fd_sc_hd__decap_8
XFILLER_13_181 VGND VGND VPWR VPWR sky130_fd_sc_hd__decap_8
X_439_ net95 net92 net90 net89 net83 net77 VGND VGND VPWR VPWR _017_ sky130_fd_sc_hd__mux4_1
X_508_ net96 _081_ VGND VGND VPWR VPWR _083_ sky130_fd_sc_hd__xnor2_1
XTAP_TAPCELL_ROW_30_157 VGND VPWR sky130_fd_sc_hd__tapvpwrvgnd_1
XFILLER_10_173 VPWR VGND VPWR VGND sky130_ef_sc_hd__decap_12
XPHY_EDGE_ROW_5_Left_37 VGND VGND VPWR VPWR sky130_fd_sc_hd__decap_3
XFILLER_6_122 VGND VGND VPWR VPWR sky130_fd_sc_hd__decap_8
XFILLER_6_188 VGND VGND VPWR VPWR sky130_fd_sc_hd__fill_2
XTAP_TAPCELL_ROW_8_92 VGND VPWR sky130_fd_sc_hd__tapvpwrvgnd_1
XFILLER_3_169 VPWR VGND VPWR VGND sky130_ef_sc_hd__decap_12
XFILLER_23_90 VGND VGND VPWR VPWR sky130_fd_sc_hd__decap_3
XFILLER_0_139 VGND VGND VPWR VPWR sky130_fd_sc_hd__fill_1
XFILLER_0_83 VGND VGND VPWR VPWR sky130_fd_sc_hd__fill_1
X_687_ net62 _252_ VGND VGND VPWR VPWR _254_ sky130_fd_sc_hd__or2_1
X_756_ net106 _309_ _310_ net54 VGND VGND VPWR VPWR _320_ sky130_fd_sc_hd__o211a_1
XPHY_EDGE_ROW_8_Left_40 VGND VGND VPWR VPWR sky130_fd_sc_hd__decap_3
XTAP_TAPCELL_ROW_5_82 VGND VPWR sky130_fd_sc_hd__tapvpwrvgnd_1
XPHY_EDGE_ROW_7_Right_7 VGND VGND VPWR VPWR sky130_fd_sc_hd__decap_3
X_610_ _171_ _174_ _180_ VGND VGND VPWR VPWR _181_ sky130_fd_sc_hd__a21o_1
X_541_ _339_ _114_ VGND VGND VPWR VPWR _115_ sky130_fd_sc_hd__nand2_1
X_472_ net106 _339_ VGND VGND VPWR VPWR _049_ sky130_fd_sc_hd__and2_1
X_739_ net10 net26 _368_ _162_ _303_ VGND VGND VPWR VPWR _304_ sky130_fd_sc_hd__a311o_1
XFILLER_26_113 VPWR VGND VPWR VGND sky130_ef_sc_hd__decap_12
XFILLER_17_157 VGND VGND VPWR VPWR sky130_fd_sc_hd__decap_4
X_386_ net89 net87 net66 net64 net83 net77 VGND VGND VPWR VPWR _341_ sky130_fd_sc_hd__mux4_1
XFILLER_2_29 VGND VGND VPWR VPWR sky130_fd_sc_hd__decap_6
X_455_ net98 net97 net15 net95 net82 net76 VGND VGND VPWR VPWR _032_ sky130_fd_sc_hd__mux4_1
X_524_ net96 _070_ VGND VGND VPWR VPWR _099_ sky130_fd_sc_hd__and2_1
XTAP_TAPCELL_ROW_30_158 VGND VPWR sky130_fd_sc_hd__tapvpwrvgnd_1
XPHY_EDGE_ROW_21_Left_53 VGND VGND VPWR VPWR sky130_fd_sc_hd__decap_3
X_438_ net72 _013_ _015_ _011_ VGND VGND VPWR VPWR _016_ sky130_fd_sc_hd__a31o_1
XFILLER_11_108 VGND VGND VPWR VPWR sky130_fd_sc_hd__decap_4
X_507_ net96 _081_ VGND VGND VPWR VPWR _082_ sky130_fd_sc_hd__nand2_1
XFILLER_9_131 VGND VGND VPWR VPWR sky130_fd_sc_hd__fill_1
XFILLER_9_142 VGND VGND VPWR VPWR sky130_fd_sc_hd__fill_1
XTAP_TAPCELL_ROW_12_103 VGND VPWR sky130_fd_sc_hd__tapvpwrvgnd_1
XFILLER_10_141 VGND VGND VPWR VPWR sky130_fd_sc_hd__fill_2
XFILLER_10_185 VGND VGND VPWR VPWR sky130_fd_sc_hd__decap_4
XTAP_TAPCELL_ROW_8_93 VGND VPWR sky130_fd_sc_hd__tapvpwrvgnd_1
XFILLER_17_48 VGND VGND VPWR VPWR sky130_fd_sc_hd__decap_8
XFILLER_17_26 VGND VGND VPWR VPWR sky130_fd_sc_hd__decap_8
XFILLER_3_137 VGND VGND VPWR VPWR sky130_fd_sc_hd__decap_6
XFILLER_17_3 VGND VGND VPWR VPWR sky130_fd_sc_hd__fill_2
XFILLER_0_107 VGND VGND VPWR VPWR sky130_fd_sc_hd__decap_4
XFILLER_0_51 VGND VGND VPWR VPWR sky130_fd_sc_hd__fill_1
XFILLER_28_69 VGND VGND VPWR VPWR sky130_fd_sc_hd__decap_6
X_755_ net27 _368_ _036_ _079_ _049_ VGND VGND VPWR VPWR _319_ sky130_fd_sc_hd__a221o_1
X_686_ net62 _252_ VGND VGND VPWR VPWR _253_ sky130_fd_sc_hd__nand2_1
XTAP_TAPCELL_ROW_5_83 VGND VPWR sky130_fd_sc_hd__tapvpwrvgnd_1
XFILLER_29_166 VGND VGND VPWR VPWR sky130_fd_sc_hd__fill_2
X_540_ _349_ _010_ _017_ _346_ VGND VGND VPWR VPWR _114_ sky130_fd_sc_hd__o22a_1
X_471_ _035_ _036_ _041_ _363_ _047_ VGND VGND VPWR VPWR _048_ sky130_fd_sc_hd__a221o_1
X_669_ net64 _227_ _236_ net58 VGND VGND VPWR VPWR _237_ sky130_fd_sc_hd__o211a_1
X_738_ net10 net26 net54 _302_ VGND VGND VPWR VPWR _303_ sky130_fd_sc_hd__o211a_1
XFILLER_26_136 VGND VGND VPWR VPWR sky130_fd_sc_hd__decap_4
XFILLER_26_125 VGND VGND VPWR VPWR sky130_fd_sc_hd__fill_1
XFILLER_6_83 VGND VGND VPWR VPWR sky130_fd_sc_hd__fill_1
X_454_ _030_ _029_ net72 VGND VGND VPWR VPWR _031_ sky130_fd_sc_hd__mux2_1
XTAP_TAPCELL_ROW_2_73 VGND VPWR sky130_fd_sc_hd__tapvpwrvgnd_1
X_523_ _097_ _360_ _096_ VGND VGND VPWR VPWR _098_ sky130_fd_sc_hd__mux2_1
X_385_ net4 net3 net88 VGND VGND VPWR VPWR _340_ sky130_fd_sc_hd__nand3b_2
XFILLER_14_139 VGND VGND VPWR VPWR sky130_fd_sc_hd__fill_1
XTAP_TAPCELL_ROW_30_159 VGND VPWR sky130_fd_sc_hd__tapvpwrvgnd_1
X_437_ _014_ net101 net79 VGND VGND VPWR VPWR _015_ sky130_fd_sc_hd__mux2_1
XTAP_TAPCELL_ROW_15_112 VGND VPWR sky130_fd_sc_hd__tapvpwrvgnd_1
XFILLER_3_40 VGND VGND VPWR VPWR sky130_fd_sc_hd__fill_2
X_506_ net31 _080_ VGND VGND VPWR VPWR _081_ sky130_fd_sc_hd__xor2_1
XFILLER_9_154 VPWR VGND VPWR VGND sky130_ef_sc_hd__decap_12
XPHY_EDGE_ROW_29_Right_29 VGND VGND VPWR VPWR sky130_fd_sc_hd__decap_3
XFILLER_22_16 VGND VGND VPWR VPWR sky130_fd_sc_hd__decap_8
Xfanout100 net12 VGND VGND VPWR VPWR net100 sky130_fd_sc_hd__buf_2
XTAP_TAPCELL_ROW_12_104 VGND VPWR sky130_fd_sc_hd__tapvpwrvgnd_1
XFILLER_8_29 VPWR VGND VPWR VGND sky130_ef_sc_hd__decap_12
XFILLER_0_85 VGND VGND VPWR VPWR sky130_fd_sc_hd__fill_2
XFILLER_0_63 VGND VGND VPWR VPWR sky130_fd_sc_hd__decap_3
XFILLER_28_59 VGND VGND VPWR VPWR sky130_fd_sc_hd__decap_3
XFILLER_28_15 VPWR VGND VPWR VGND sky130_ef_sc_hd__decap_12
X_685_ net24 _250_ VGND VGND VPWR VPWR _252_ sky130_fd_sc_hd__xnor2_1
X_754_ net103 net101 _278_ _317_ _367_ VGND VGND VPWR VPWR _318_ sky130_fd_sc_hd__a311o_1
XTAP_TAPCELL_ROW_5_84 VGND VPWR sky130_fd_sc_hd__tapvpwrvgnd_1
XFILLER_30_27 VGND VGND VPWR VPWR sky130_fd_sc_hd__fill_1
XFILLER_29_189 VGND VGND VPWR VPWR sky130_fd_sc_hd__fill_1
XFILLER_29_145 VGND VGND VPWR VPWR sky130_fd_sc_hd__fill_1
XFILLER_14_17 VGND VGND VPWR VPWR sky130_fd_sc_hd__fill_2
X_737_ net106 _338_ net26 VGND VGND VPWR VPWR _302_ sky130_fd_sc_hd__or3b_1
X_668_ net64 _227_ VGND VGND VPWR VPWR _236_ sky130_fd_sc_hd__nand2_1
X_599_ _105_ _083_ _104_ VGND VGND VPWR VPWR _170_ sky130_fd_sc_hd__or3b_1
X_470_ net73 net99 _368_ _043_ _046_ VGND VGND VPWR VPWR _047_ sky130_fd_sc_hd__a311o_1
XFILLER_25_27 VGND VGND VPWR VPWR sky130_fd_sc_hd__fill_1
XFILLER_6_40 VGND VGND VPWR VPWR sky130_fd_sc_hd__decap_3
XFILLER_25_181 VGND VGND VPWR VPWR sky130_fd_sc_hd__decap_8
X_453_ net66 net65 net62 net60 net84 net78 VGND VGND VPWR VPWR _030_ sky130_fd_sc_hd__mux4_1
X_522_ net96 net31 net54 VGND VGND VPWR VPWR _097_ sky130_fd_sc_hd__o21ai_1
X_384_ net4 net3 net88 VGND VGND VPWR VPWR _339_ sky130_fd_sc_hd__and3b_2
XFILLER_23_118 VGND VGND VPWR VPWR sky130_fd_sc_hd__fill_2
XFILLER_23_107 VGND VGND VPWR VPWR sky130_fd_sc_hd__decap_4
XTAP_TAPCELL_ROW_18_121 VGND VPWR sky130_fd_sc_hd__tapvpwrvgnd_1
XTAP_TAPCELL_ROW_2_74 VGND VPWR sky130_fd_sc_hd__tapvpwrvgnd_1
XFILLER_14_129 VGND VGND VPWR VPWR sky130_fd_sc_hd__decap_3
X_436_ net61 net10 net86 VGND VGND VPWR VPWR _014_ sky130_fd_sc_hd__mux2_1
XTAP_TAPCELL_ROW_15_113 VGND VPWR sky130_fd_sc_hd__tapvpwrvgnd_1
XFILLER_13_151 VGND VGND VPWR VPWR sky130_fd_sc_hd__fill_1
X_505_ net57 _078_ VGND VGND VPWR VPWR _080_ sky130_fd_sc_hd__nand2_1
XFILLER_9_111 VGND VGND VPWR VPWR sky130_fd_sc_hd__fill_1
XFILLER_9_166 VGND VGND VPWR VPWR sky130_fd_sc_hd__fill_2
Xfanout101 net11 VGND VGND VPWR VPWR net101 sky130_fd_sc_hd__buf_2
XTAP_TAPCELL_ROW_12_105 VGND VPWR sky130_fd_sc_hd__tapvpwrvgnd_1
XFILLER_12_83 VGND VGND VPWR VPWR sky130_fd_sc_hd__fill_1
X_419_ net85 net79 net57 VGND VGND VPWR VPWR _373_ sky130_fd_sc_hd__and3_1
XFILLER_24_6 VPWR VGND VPWR VGND sky130_ef_sc_hd__decap_12
XFILLER_0_97 VGND VGND VPWR VPWR sky130_fd_sc_hd__fill_2
XFILLER_0_20 VGND VGND VPWR VPWR sky130_fd_sc_hd__decap_8
XFILLER_9_84 VPWR VGND VPWR VGND sky130_ef_sc_hd__decap_12
XFILLER_28_27 VGND VGND VPWR VPWR sky130_fd_sc_hd__fill_1
X_684_ net23 net56 _231_ net24 VGND VGND VPWR VPWR _251_ sky130_fd_sc_hd__a211o_1
X_753_ net103 _278_ net101 VGND VGND VPWR VPWR _317_ sky130_fd_sc_hd__a21oi_1
XFILLER_18_82 VGND VGND VPWR VPWR sky130_fd_sc_hd__fill_2
XFILLER_29_92 VGND VGND VPWR VPWR sky130_fd_sc_hd__decap_4
XFILLER_20_83 VGND VGND VPWR VPWR sky130_fd_sc_hd__fill_1
X_736_ _029_ _036_ _300_ _361_ VGND VGND VPWR VPWR _301_ sky130_fd_sc_hd__a22o_1
X_667_ _211_ _218_ _233_ VGND VGND VPWR VPWR _235_ sky130_fd_sc_hd__or3_1
X_598_ _130_ _153_ VGND VGND VPWR VPWR _169_ sky130_fd_sc_hd__or2_1
XFILLER_6_52 VGND VGND VPWR VPWR sky130_fd_sc_hd__decap_4
XFILLER_6_85 VPWR VGND VPWR VGND sky130_ef_sc_hd__decap_12
X_383_ net103 VGND VGND VPWR VPWR _338_ sky130_fd_sc_hd__inv_2
X_452_ net79 _342_ VGND VGND VPWR VPWR _029_ sky130_fd_sc_hd__and2b_1
XFILLER_15_50 VGND VGND VPWR VPWR sky130_fd_sc_hd__decap_6
X_521_ net104 net96 net31 VGND VGND VPWR VPWR _096_ sky130_fd_sc_hd__and3b_1
XFILLER_31_141 VGND VGND VPWR VPWR sky130_fd_sc_hd__fill_2
X_719_ net61 net25 net54 _284_ VGND VGND VPWR VPWR _285_ sky130_fd_sc_hd__o211a_1
XTAP_TAPCELL_ROW_18_122 VGND VPWR sky130_fd_sc_hd__tapvpwrvgnd_1
XFILLER_16_171 VGND VGND VPWR VPWR sky130_fd_sc_hd__fill_2
XTAP_TAPCELL_ROW_2_75 VGND VPWR sky130_fd_sc_hd__tapvpwrvgnd_1
XFILLER_22_141 VPWR VGND VPWR VGND sky130_ef_sc_hd__decap_12
XFILLER_14_119 VGND VGND VPWR VPWR sky130_fd_sc_hd__fill_1
X_504_ _078_ VGND VGND VPWR VPWR _079_ sky130_fd_sc_hd__inv_2
X_435_ net105 net85 _012_ VGND VGND VPWR VPWR _013_ sky130_fd_sc_hd__nand3b_1
XTAP_TAPCELL_ROW_15_114 VGND VPWR sky130_fd_sc_hd__tapvpwrvgnd_1
XFILLER_9_189 VGND VGND VPWR VPWR sky130_fd_sc_hd__fill_1
Xfanout102 net11 VGND VGND VPWR VPWR net102 sky130_fd_sc_hd__buf_1
XPHY_EDGE_ROW_25_Left_57 VGND VGND VPWR VPWR sky130_fd_sc_hd__decap_3
X_418_ net88 net3 net4 net104 VGND VGND VPWR VPWR _372_ sky130_fd_sc_hd__or4b_1
XFILLER_5_181 VGND VGND VPWR VPWR sky130_fd_sc_hd__decap_6
XFILLER_9_96 VGND VGND VPWR VPWR sky130_fd_sc_hd__decap_3
X_752_ _371_ _314_ _315_ VGND VGND VPWR VPWR _316_ sky130_fd_sc_hd__or3_1
X_683_ net23 net56 _231_ VGND VGND VPWR VPWR _250_ sky130_fd_sc_hd__a21o_1
XFILLER_30_29 VGND VGND VPWR VPWR sky130_fd_sc_hd__decap_4
XPHY_EDGE_ROW_28_Left_60 VGND VGND VPWR VPWR sky130_fd_sc_hd__decap_3
XPHY_EDGE_ROW_12_Left_44 VGND VGND VPWR VPWR sky130_fd_sc_hd__decap_3
XFILLER_29_169 VPWR VGND VPWR VGND sky130_ef_sc_hd__decap_12
XFILLER_29_158 VGND VGND VPWR VPWR sky130_fd_sc_hd__decap_8
XFILLER_29_125 VGND VGND VPWR VPWR sky130_fd_sc_hd__fill_2
X_666_ _211_ _218_ _233_ VGND VGND VPWR VPWR _234_ sky130_fd_sc_hd__o21ai_1
X_735_ net103 net60 net62 net65 net86 net80 VGND VGND VPWR VPWR _300_ sky130_fd_sc_hd__mux4_1
X_597_ _370_ _154_ _155_ _168_ VGND VGND VPWR VPWR net50 sky130_fd_sc_hd__a31o_1
XFILLER_6_75 VGND VGND VPWR VPWR sky130_fd_sc_hd__decap_4
XFILLER_6_97 VGND VGND VPWR VPWR sky130_fd_sc_hd__decap_4
X_520_ net68 _093_ _094_ _089_ _091_ VGND VGND VPWR VPWR _095_ sky130_fd_sc_hd__a32o_1
X_649_ _214_ _216_ _212_ VGND VGND VPWR VPWR _218_ sky130_fd_sc_hd__a21oi_1
X_718_ net106 net61 net25 VGND VGND VPWR VPWR _284_ sky130_fd_sc_hd__nand3b_1
X_382_ net64 VGND VGND VPWR VPWR _337_ sky130_fd_sc_hd__inv_2
XTAP_TAPCELL_ROW_18_123 VGND VPWR sky130_fd_sc_hd__tapvpwrvgnd_1
Xoutput50 net50 VGND VGND VPWR VPWR ALU_result[7] sky130_fd_sc_hd__buf_2
X_451_ _022_ _026_ VGND VGND VPWR VPWR _028_ sky130_fd_sc_hd__or2_1
XFILLER_26_83 VGND VGND VPWR VPWR sky130_fd_sc_hd__fill_1
XFILLER_26_61 VGND VGND VPWR VPWR sky130_fd_sc_hd__decap_6
XFILLER_22_153 VGND VGND VPWR VPWR sky130_fd_sc_hd__decap_4
X_434_ net79 _338_ net85 VGND VGND VPWR VPWR _012_ sky130_fd_sc_hd__or3b_1
X_503_ net68 net74 net83 net77 VGND VGND VPWR VPWR _078_ sky130_fd_sc_hd__or4_4
XFILLER_9_113 VGND VGND VPWR VPWR sky130_fd_sc_hd__decap_3
Xfanout103 net10 VGND VGND VPWR VPWR net103 sky130_fd_sc_hd__buf_2
XFILLER_12_85 VGND VGND VPWR VPWR sky130_fd_sc_hd__decap_4
XFILLER_10_189 VGND VGND VPWR VPWR sky130_fd_sc_hd__fill_1
XPHY_EDGE_ROW_0_Left_32 VGND VGND VPWR VPWR sky130_fd_sc_hd__decap_3
XPHY_EDGE_ROW_25_Right_25 VGND VGND VPWR VPWR sky130_fd_sc_hd__decap_3
XPHY_EDGE_ROW_16_Right_16 VGND VGND VPWR VPWR sky130_fd_sc_hd__decap_3
X_417_ net88 net3 net4 VGND VGND VPWR VPWR _371_ sky130_fd_sc_hd__or3_4
XFILLER_5_160 VGND VGND VPWR VPWR sky130_fd_sc_hd__decap_8
XFILLER_2_141 VGND VGND VPWR VPWR sky130_fd_sc_hd__decap_6
XFILLER_28_29 VGND VGND VPWR VPWR sky130_fd_sc_hd__fill_1
X_751_ _292_ _296_ _313_ VGND VGND VPWR VPWR _315_ sky130_fd_sc_hd__a21oi_1
X_682_ _337_ _232_ _246_ _216_ _248_ VGND VGND VPWR VPWR _249_ sky130_fd_sc_hd__o221a_1
XFILLER_30_19 VGND VGND VPWR VPWR sky130_fd_sc_hd__decap_8
XPHY_EDGE_ROW_2_Right_2 VGND VGND VPWR VPWR sky130_fd_sc_hd__decap_3
X_665_ net64 _232_ VGND VGND VPWR VPWR _233_ sky130_fd_sc_hd__xnor2_1
X_734_ net103 _278_ _298_ net58 VGND VGND VPWR VPWR _299_ sky130_fd_sc_hd__o211a_1
XFILLER_20_85 VGND VGND VPWR VPWR sky130_fd_sc_hd__decap_4
XFILLER_20_41 VPWR VGND VPWR VGND sky130_ef_sc_hd__decap_12
X_596_ _339_ _157_ _167_ VGND VGND VPWR VPWR _168_ sky130_fd_sc_hd__a21bo_1
XFILLER_6_10 VGND VGND VPWR VPWR sky130_fd_sc_hd__fill_1
XFILLER_19_181 VGND VGND VPWR VPWR sky130_fd_sc_hd__fill_1
Xoutput40 net40 VGND VGND VPWR VPWR ALU_result[12] sky130_fd_sc_hd__buf_2
X_381_ net66 VGND VGND VPWR VPWR _336_ sky130_fd_sc_hd__inv_2
Xoutput51 net51 VGND VGND VPWR VPWR ALU_result[8] sky130_fd_sc_hd__buf_2
X_450_ _022_ _026_ VGND VGND VPWR VPWR _027_ sky130_fd_sc_hd__nand2_1
XFILLER_31_154 VPWR VGND VPWR VGND sky130_ef_sc_hd__decap_12
XFILLER_31_132 VGND VGND VPWR VPWR sky130_fd_sc_hd__decap_4
X_648_ _212_ _214_ _216_ VGND VGND VPWR VPWR _217_ sky130_fd_sc_hd__and3_1
X_579_ net31 net32 net33 _078_ net56 VGND VGND VPWR VPWR _151_ sky130_fd_sc_hd__o41a_1
X_717_ net69 _113_ _119_ _282_ VGND VGND VPWR VPWR _283_ sky130_fd_sc_hd__a22o_1
XFILLER_26_51 VGND VGND VPWR VPWR sky130_fd_sc_hd__decap_3
X_433_ net72 _010_ VGND VGND VPWR VPWR _011_ sky130_fd_sc_hd__and2b_1
X_502_ _370_ _059_ _077_ VGND VGND VPWR VPWR net46 sky130_fd_sc_hd__a21o_1
XFILLER_13_165 VGND VGND VPWR VPWR sky130_fd_sc_hd__decap_3
XFILLER_3_55 VGND VGND VPWR VPWR sky130_fd_sc_hd__fill_1
XFILLER_3_66 VGND VGND VPWR VPWR sky130_fd_sc_hd__fill_2
XFILLER_9_169 VPWR VGND VPWR VGND sky130_ef_sc_hd__decap_12
XFILLER_10_102 VGND VGND VPWR VPWR sky130_fd_sc_hd__decap_4
Xfanout104 net106 VGND VGND VPWR VPWR net104 sky130_fd_sc_hd__buf_2
X_416_ net88 _356_ VGND VGND VPWR VPWR _370_ sky130_fd_sc_hd__and2b_2
XFILLER_5_3 VPWR VGND VPWR VGND sky130_ef_sc_hd__decap_12
XFILLER_6_139 VGND VGND VPWR VPWR sky130_fd_sc_hd__fill_1
XFILLER_0_34 VGND VGND VPWR VPWR sky130_fd_sc_hd__decap_4
XFILLER_9_10 VGND VGND VPWR VPWR sky130_fd_sc_hd__decap_8
X_681_ _337_ _232_ _210_ _336_ VGND VGND VPWR VPWR _248_ sky130_fd_sc_hd__a211o_1
X_750_ _292_ _296_ _313_ VGND VGND VPWR VPWR _314_ sky130_fd_sc_hd__and3_1
XFILLER_18_85 VPWR VGND VPWR VGND sky130_ef_sc_hd__decap_12
XFILLER_18_74 VGND VGND VPWR VPWR sky130_fd_sc_hd__decap_4
XFILLER_29_84 VGND VGND VPWR VPWR sky130_fd_sc_hd__fill_1
X_664_ net23 _231_ VGND VGND VPWR VPWR _232_ sky130_fd_sc_hd__xor2_1
X_733_ net103 _278_ VGND VGND VPWR VPWR _298_ sky130_fd_sc_hd__nand2_1
XFILLER_20_53 VGND VGND VPWR VPWR sky130_fd_sc_hd__decap_3
X_595_ _367_ _158_ _159_ _166_ VGND VGND VPWR VPWR _167_ sky130_fd_sc_hd__o31a_1
XFILLER_6_33 VGND VGND VPWR VPWR sky130_fd_sc_hd__fill_1
Xoutput41 net41 VGND VGND VPWR VPWR ALU_result[13] sky130_fd_sc_hd__buf_2
Xoutput52 net52 VGND VGND VPWR VPWR ALU_result[9] sky130_fd_sc_hd__buf_2
XFILLER_31_41 VPWR VGND VPWR VGND sky130_ef_sc_hd__decap_12
X_380_ net87 VGND VGND VPWR VPWR _335_ sky130_fd_sc_hd__inv_2
XFILLER_17_108 VGND VGND VPWR VPWR sky130_fd_sc_hd__decap_4
XFILLER_15_31 VGND VGND VPWR VPWR sky130_fd_sc_hd__decap_8
XFILLER_31_166 VGND VGND VPWR VPWR sky130_fd_sc_hd__fill_2
X_647_ _335_ _195_ _215_ VGND VGND VPWR VPWR _216_ sky130_fd_sc_hd__a21o_1
X_716_ _361_ _281_ VGND VGND VPWR VPWR _282_ sky130_fd_sc_hd__nand2_1
XFILLER_16_141 VGND VGND VPWR VPWR sky130_fd_sc_hd__fill_1
X_578_ _133_ _134_ _150_ VGND VGND VPWR VPWR net49 sky130_fd_sc_hd__o21ai_1
.ends
