* NGSPICE file created from Data_Memory.ext - technology: sky130A

* Black-box entry subcircuit for sky130_fd_sc_hd__decap_8 abstract view
.subckt sky130_fd_sc_hd__decap_8 VGND VNB VPB VPWR
.ends

* Black-box entry subcircuit for sky130_fd_sc_hd__or2_1 abstract view
.subckt sky130_fd_sc_hd__or2_1 A B VGND VNB VPB VPWR X
.ends

* Black-box entry subcircuit for sky130_fd_sc_hd__mux2_1 abstract view
.subckt sky130_fd_sc_hd__mux2_1 A0 A1 S VGND VNB VPB VPWR X
.ends

* Black-box entry subcircuit for sky130_fd_sc_hd__decap_6 abstract view
.subckt sky130_fd_sc_hd__decap_6 VGND VNB VPB VPWR
.ends

* Black-box entry subcircuit for sky130_fd_sc_hd__tapvpwrvgnd_1 abstract view
.subckt sky130_fd_sc_hd__tapvpwrvgnd_1 VGND VPWR
.ends

* Black-box entry subcircuit for sky130_fd_sc_hd__decap_3 abstract view
.subckt sky130_fd_sc_hd__decap_3 VGND VNB VPB VPWR
.ends

* Black-box entry subcircuit for sky130_fd_sc_hd__decap_4 abstract view
.subckt sky130_fd_sc_hd__decap_4 VGND VNB VPB VPWR
.ends

* Black-box entry subcircuit for sky130_fd_sc_hd__clkbuf_8 abstract view
.subckt sky130_fd_sc_hd__clkbuf_8 A VGND VNB VPB VPWR X
.ends

* Black-box entry subcircuit for sky130_ef_sc_hd__decap_12 abstract view
.subckt sky130_ef_sc_hd__decap_12 VPWR VGND VPB VNB
.ends

* Black-box entry subcircuit for sky130_fd_sc_hd__fill_2 abstract view
.subckt sky130_fd_sc_hd__fill_2 VGND VNB VPB VPWR
.ends

* Black-box entry subcircuit for sky130_fd_sc_hd__dlygate4sd3_1 abstract view
.subckt sky130_fd_sc_hd__dlygate4sd3_1 A VGND VNB VPB VPWR X
.ends

* Black-box entry subcircuit for sky130_fd_sc_hd__dfxtp_1 abstract view
.subckt sky130_fd_sc_hd__dfxtp_1 CLK D VGND VNB VPB VPWR Q
.ends

* Black-box entry subcircuit for sky130_fd_sc_hd__buf_2 abstract view
.subckt sky130_fd_sc_hd__buf_2 A VGND VNB VPB VPWR X
.ends

* Black-box entry subcircuit for sky130_fd_sc_hd__fill_1 abstract view
.subckt sky130_fd_sc_hd__fill_1 VGND VNB VPB VPWR
.ends

* Black-box entry subcircuit for sky130_fd_sc_hd__a22o_1 abstract view
.subckt sky130_fd_sc_hd__a22o_1 A1 A2 B1 B2 VGND VNB VPB VPWR X
.ends

* Black-box entry subcircuit for sky130_fd_sc_hd__a21o_1 abstract view
.subckt sky130_fd_sc_hd__a21o_1 A1 A2 B1 VGND VNB VPB VPWR X
.ends

* Black-box entry subcircuit for sky130_fd_sc_hd__and2_1 abstract view
.subckt sky130_fd_sc_hd__and2_1 A B VGND VNB VPB VPWR X
.ends

* Black-box entry subcircuit for sky130_fd_sc_hd__o31a_1 abstract view
.subckt sky130_fd_sc_hd__o31a_1 A1 A2 A3 B1 VGND VNB VPB VPWR X
.ends

* Black-box entry subcircuit for sky130_fd_sc_hd__inv_2 abstract view
.subckt sky130_fd_sc_hd__inv_2 A VGND VNB VPB VPWR Y
.ends

* Black-box entry subcircuit for sky130_fd_sc_hd__o21a_1 abstract view
.subckt sky130_fd_sc_hd__o21a_1 A1 A2 B1 VGND VNB VPB VPWR X
.ends

* Black-box entry subcircuit for sky130_fd_sc_hd__clkinv_2 abstract view
.subckt sky130_fd_sc_hd__clkinv_2 A VGND VNB VPB VPWR Y
.ends

* Black-box entry subcircuit for sky130_fd_sc_hd__clkbuf_4 abstract view
.subckt sky130_fd_sc_hd__clkbuf_4 A VGND VNB VPB VPWR X
.ends

* Black-box entry subcircuit for sky130_fd_sc_hd__o221a_1 abstract view
.subckt sky130_fd_sc_hd__o221a_1 A1 A2 B1 B2 C1 VGND VNB VPB VPWR X
.ends

* Black-box entry subcircuit for sky130_fd_sc_hd__a221o_1 abstract view
.subckt sky130_fd_sc_hd__a221o_1 A1 A2 B1 B2 C1 VGND VNB VPB VPWR X
.ends

* Black-box entry subcircuit for sky130_fd_sc_hd__buf_4 abstract view
.subckt sky130_fd_sc_hd__buf_4 A VGND VNB VPB VPWR X
.ends

* Black-box entry subcircuit for sky130_fd_sc_hd__bufinv_16 abstract view
.subckt sky130_fd_sc_hd__bufinv_16 A VGND VNB VPB VPWR Y
.ends

* Black-box entry subcircuit for sky130_fd_sc_hd__clkbuf_16 abstract view
.subckt sky130_fd_sc_hd__clkbuf_16 A VGND VNB VPB VPWR X
.ends

* Black-box entry subcircuit for sky130_fd_sc_hd__clkbuf_2 abstract view
.subckt sky130_fd_sc_hd__clkbuf_2 A VGND VNB VPB VPWR X
.ends

* Black-box entry subcircuit for sky130_fd_sc_hd__o311a_1 abstract view
.subckt sky130_fd_sc_hd__o311a_1 A1 A2 A3 B1 C1 VGND VNB VPB VPWR X
.ends

* Black-box entry subcircuit for sky130_fd_sc_hd__clkbuf_1 abstract view
.subckt sky130_fd_sc_hd__clkbuf_1 A VGND VNB VPB VPWR X
.ends

* Black-box entry subcircuit for sky130_fd_sc_hd__buf_1 abstract view
.subckt sky130_fd_sc_hd__buf_1 A VGND VNB VPB VPWR X
.ends

* Black-box entry subcircuit for sky130_fd_sc_hd__and3b_1 abstract view
.subckt sky130_fd_sc_hd__and3b_1 A_N B C VGND VNB VPB VPWR X
.ends

* Black-box entry subcircuit for sky130_fd_sc_hd__and3_1 abstract view
.subckt sky130_fd_sc_hd__and3_1 A B C VGND VNB VPB VPWR X
.ends

* Black-box entry subcircuit for sky130_fd_sc_hd__nor2_1 abstract view
.subckt sky130_fd_sc_hd__nor2_1 A B VGND VNB VPB VPWR Y
.ends

* Black-box entry subcircuit for sky130_fd_sc_hd__or3b_1 abstract view
.subckt sky130_fd_sc_hd__or3b_1 A B C_N VGND VNB VPB VPWR X
.ends

* Black-box entry subcircuit for sky130_fd_sc_hd__and2b_1 abstract view
.subckt sky130_fd_sc_hd__and2b_1 A_N B VGND VNB VPB VPWR X
.ends

.subckt Data_Memory VGND VPWR clk mem_access_addr[0] mem_access_addr[10] mem_access_addr[11]
+ mem_access_addr[12] mem_access_addr[13] mem_access_addr[14] mem_access_addr[15]
+ mem_access_addr[1] mem_access_addr[2] mem_access_addr[3] mem_access_addr[4] mem_access_addr[5]
+ mem_access_addr[6] mem_access_addr[7] mem_access_addr[8] mem_access_addr[9] mem_read
+ mem_read_data[0] mem_read_data[10] mem_read_data[11] mem_read_data[12] mem_read_data[13]
+ mem_read_data[14] mem_read_data[15] mem_read_data[1] mem_read_data[2] mem_read_data[3]
+ mem_read_data[4] mem_read_data[5] mem_read_data[6] mem_read_data[7] mem_read_data[8]
+ mem_read_data[9] mem_write_data[0] mem_write_data[10] mem_write_data[11] mem_write_data[12]
+ mem_write_data[13] mem_write_data[14] mem_write_data[15] mem_write_data[1] mem_write_data[2]
+ mem_write_data[3] mem_write_data[4] mem_write_data[5] mem_write_data[6] mem_write_data[7]
+ mem_write_data[8] mem_write_data[9] mem_write_en
XFILLER_22_188 VGND VGND VPWR VPWR sky130_fd_sc_hd__decap_8
XFILLER_22_122 VGND VGND VPWR VPWR sky130_fd_sc_hd__decap_8
X_501_ net5 net62 VGND VGND VPWR VPWR _140_ sky130_fd_sc_hd__or2_1
X_432_ net6 net192 net45 VGND VGND VPWR VPWR _074_ sky130_fd_sc_hd__mux2_1
X_363_ net98 net20 net52 VGND VGND VPWR VPWR _009_ sky130_fd_sc_hd__mux2_1
X_294_ memory\[4\]\[9\] memory\[5\]\[9\] net70 VGND VGND VPWR VPWR _207_ sky130_fd_sc_hd__mux2_1
XFILLER_3_89 VGND VGND VPWR VPWR sky130_fd_sc_hd__decap_6
XTAP_TAPCELL_ROW_37_231 VGND VPWR sky130_fd_sc_hd__tapvpwrvgnd_1
XFILLER_27_225 VGND VGND VPWR VPWR sky130_fd_sc_hd__decap_3
XTAP_TAPCELL_ROW_6_107 VGND VPWR sky130_fd_sc_hd__tapvpwrvgnd_1
XFILLER_8_192 VGND VGND VPWR VPWR sky130_fd_sc_hd__decap_4
XFILLER_37_51 VGND VGND VPWR VPWR sky130_fd_sc_hd__decap_4
X_346_ memory\[0\]\[15\] memory\[1\]\[15\] net76 VGND VGND VPWR VPWR _253_ sky130_fd_sc_hd__mux2_1
X_415_ net93 net6 net47 VGND VGND VPWR VPWR _058_ sky130_fd_sc_hd__mux2_1
XTAP_TAPCELL_ROW_20_164 VGND VPWR sky130_fd_sc_hd__tapvpwrvgnd_1
Xclkbuf_4_12_0_clk clknet_0_clk VGND VGND VPWR VPWR clknet_4_12_0_clk sky130_fd_sc_hd__clkbuf_8
XFILLER_24_206 VGND VGND VPWR VPWR sky130_fd_sc_hd__decap_3
X_277_ memory\[6\]\[7\] memory\[7\]\[7\] net69 VGND VGND VPWR VPWR _192_ sky130_fd_sc_hd__mux2_1
X_329_ memory\[2\]\[13\] memory\[3\]\[13\] net74 VGND VGND VPWR VPWR _238_ sky130_fd_sc_hd__mux2_1
XFILLER_2_121 VGND VGND VPWR VPWR sky130_fd_sc_hd__decap_8
XFILLER_0_57 VPWR VGND VPWR VGND sky130_ef_sc_hd__decap_12
XFILLER_0_35 VPWR VGND VPWR VGND sky130_ef_sc_hd__decap_12
XPHY_EDGE_ROW_8_Left_47 VGND VGND VPWR VPWR sky130_fd_sc_hd__decap_3
XFILLER_34_96 VGND VGND VPWR VPWR sky130_fd_sc_hd__decap_6
XFILLER_34_85 VGND VGND VPWR VPWR sky130_fd_sc_hd__fill_2
XFILLER_34_74 VGND VGND VPWR VPWR sky130_fd_sc_hd__decap_8
XFILLER_22_7 VGND VGND VPWR VPWR sky130_fd_sc_hd__decap_6
XFILLER_37_161 VGND VGND VPWR VPWR sky130_fd_sc_hd__decap_6
Xhold74 memory\[3\]\[4\] VGND VGND VPWR VPWR net152 sky130_fd_sc_hd__dlygate4sd3_1
Xhold63 memory\[7\]\[4\] VGND VGND VPWR VPWR net141 sky130_fd_sc_hd__dlygate4sd3_1
X_594_ clknet_4_4_0_clk _044_ VGND VGND VPWR VPWR memory\[3\]\[12\] sky130_fd_sc_hd__dfxtp_1
Xhold30 memory\[4\]\[8\] VGND VGND VPWR VPWR net108 sky130_fd_sc_hd__dlygate4sd3_1
Xhold85 memory\[3\]\[13\] VGND VGND VPWR VPWR net163 sky130_fd_sc_hd__dlygate4sd3_1
X_663_ clknet_4_11_0_clk _113_ VGND VGND VPWR VPWR memory\[7\]\[1\] sky130_fd_sc_hd__dfxtp_1
Xhold41 memory\[2\]\[8\] VGND VGND VPWR VPWR net119 sky130_fd_sc_hd__dlygate4sd3_1
Xhold52 memory\[3\]\[9\] VGND VGND VPWR VPWR net130 sky130_fd_sc_hd__dlygate4sd3_1
Xhold96 memory\[0\]\[14\] VGND VGND VPWR VPWR net174 sky130_fd_sc_hd__dlygate4sd3_1
XFILLER_34_197 VGND VGND VPWR VPWR sky130_fd_sc_hd__decap_3
XFILLER_13_3 VGND VGND VPWR VPWR sky130_fd_sc_hd__decap_3
XFILLER_31_53 VGND VGND VPWR VPWR sky130_fd_sc_hd__decap_3
XFILLER_1_219 VGND VGND VPWR VPWR sky130_fd_sc_hd__decap_4
X_646_ clknet_4_7_0_clk _096_ VGND VGND VPWR VPWR memory\[1\]\[0\] sky130_fd_sc_hd__dfxtp_1
Xoutput31 net31 VGND VGND VPWR VPWR mem_read_data[3] sky130_fd_sc_hd__buf_2
XFILLER_16_186 VGND VGND VPWR VPWR sky130_fd_sc_hd__fill_1
X_577_ clknet_4_2_0_clk _027_ VGND VGND VPWR VPWR memory\[4\]\[11\] sky130_fd_sc_hd__dfxtp_1
XFILLER_22_145 VGND VGND VPWR VPWR sky130_fd_sc_hd__decap_3
XPHY_EDGE_ROW_37_Left_76 VGND VGND VPWR VPWR sky130_fd_sc_hd__decap_3
X_500_ net56 _136_ net55 _138_ VGND VGND VPWR VPWR _139_ sky130_fd_sc_hd__a22o_1
XFILLER_26_53 VGND VGND VPWR VPWR sky130_fd_sc_hd__decap_4
X_362_ net126 net19 net53 VGND VGND VPWR VPWR _008_ sky130_fd_sc_hd__mux2_1
X_293_ net54 _205_ net66 VGND VGND VPWR VPWR _206_ sky130_fd_sc_hd__a21o_1
X_431_ net20 net205 net44 VGND VGND VPWR VPWR _073_ sky130_fd_sc_hd__mux2_1
XFILLER_13_178 VGND VGND VPWR VPWR sky130_fd_sc_hd__decap_3
X_629_ clknet_4_13_0_clk _079_ VGND VGND VPWR VPWR memory\[0\]\[15\] sky130_fd_sc_hd__dfxtp_1
XTAP_TAPCELL_ROW_14_140 VGND VPWR sky130_fd_sc_hd__tapvpwrvgnd_1
XTAP_TAPCELL_ROW_6_108 VGND VPWR sky130_fd_sc_hd__tapvpwrvgnd_1
XTAP_TAPCELL_ROW_37_232 VGND VPWR sky130_fd_sc_hd__tapvpwrvgnd_1
XTAP_TAPCELL_ROW_20_165 VGND VPWR sky130_fd_sc_hd__tapvpwrvgnd_1
X_345_ net57 _251_ VGND VGND VPWR VPWR _252_ sky130_fd_sc_hd__and2_1
X_414_ net80 net20 net46 VGND VGND VPWR VPWR _057_ sky130_fd_sc_hd__mux2_1
X_276_ memory\[0\]\[7\] memory\[1\]\[7\] net70 VGND VGND VPWR VPWR _191_ sky130_fd_sc_hd__mux2_1
XFILLER_5_130 VGND VGND VPWR VPWR sky130_fd_sc_hd__fill_1
XPHY_EDGE_ROW_21_Right_21 VGND VGND VPWR VPWR sky130_fd_sc_hd__decap_3
XPHY_EDGE_ROW_12_Right_12 VGND VGND VPWR VPWR sky130_fd_sc_hd__decap_3
XPHY_EDGE_ROW_30_Right_30 VGND VGND VPWR VPWR sky130_fd_sc_hd__decap_3
X_328_ memory\[4\]\[13\] memory\[5\]\[13\] net77 VGND VGND VPWR VPWR _237_ sky130_fd_sc_hd__mux2_1
XFILLER_0_69 VPWR VGND VPWR VGND sky130_ef_sc_hd__decap_12
XFILLER_0_47 VGND VGND VPWR VPWR sky130_fd_sc_hd__decap_4
XFILLER_2_166 VPWR VGND VPWR VGND sky130_ef_sc_hd__decap_12
XPHY_EDGE_ROW_24_Left_63 VGND VGND VPWR VPWR sky130_fd_sc_hd__decap_3
XFILLER_34_42 VGND VGND VPWR VPWR sky130_fd_sc_hd__decap_3
XFILLER_7_225 VGND VGND VPWR VPWR sky130_fd_sc_hd__decap_3
Xclkbuf_4_11_0_clk clknet_0_clk VGND VGND VPWR VPWR clknet_4_11_0_clk sky130_fd_sc_hd__clkbuf_8
Xhold86 memory\[7\]\[0\] VGND VGND VPWR VPWR net164 sky130_fd_sc_hd__dlygate4sd3_1
X_662_ clknet_4_7_0_clk _112_ VGND VGND VPWR VPWR memory\[7\]\[0\] sky130_fd_sc_hd__dfxtp_1
Xhold53 memory\[4\]\[10\] VGND VGND VPWR VPWR net131 sky130_fd_sc_hd__dlygate4sd3_1
Xhold31 memory\[7\]\[5\] VGND VGND VPWR VPWR net109 sky130_fd_sc_hd__dlygate4sd3_1
Xhold97 memory\[3\]\[10\] VGND VGND VPWR VPWR net175 sky130_fd_sc_hd__dlygate4sd3_1
Xhold20 memory\[5\]\[9\] VGND VGND VPWR VPWR net98 sky130_fd_sc_hd__dlygate4sd3_1
XFILLER_20_22 VGND VGND VPWR VPWR sky130_fd_sc_hd__decap_6
Xhold64 memory\[5\]\[7\] VGND VGND VPWR VPWR net142 sky130_fd_sc_hd__dlygate4sd3_1
Xhold75 memory\[7\]\[1\] VGND VGND VPWR VPWR net153 sky130_fd_sc_hd__dlygate4sd3_1
Xhold42 memory\[4\]\[6\] VGND VGND VPWR VPWR net120 sky130_fd_sc_hd__dlygate4sd3_1
XFILLER_28_195 VGND VGND VPWR VPWR sky130_fd_sc_hd__fill_1
X_593_ clknet_4_3_0_clk _043_ VGND VGND VPWR VPWR memory\[3\]\[11\] sky130_fd_sc_hd__dfxtp_1
XFILLER_6_57 VGND VGND VPWR VPWR sky130_fd_sc_hd__fill_2
XFILLER_15_11 VGND VGND VPWR VPWR sky130_fd_sc_hd__fill_1
XPHY_EDGE_ROW_11_Left_50 VGND VGND VPWR VPWR sky130_fd_sc_hd__decap_3
XPHY_EDGE_ROW_6_Right_6 VGND VGND VPWR VPWR sky130_fd_sc_hd__decap_3
XFILLER_31_113 VPWR VGND VPWR VGND sky130_ef_sc_hd__decap_12
XFILLER_31_87 VGND VGND VPWR VPWR sky130_fd_sc_hd__decap_4
Xoutput32 net32 VGND VGND VPWR VPWR mem_read_data[4] sky130_fd_sc_hd__buf_2
X_645_ clknet_4_13_0_clk _095_ VGND VGND VPWR VPWR memory\[6\]\[15\] sky130_fd_sc_hd__dfxtp_1
X_576_ clknet_4_12_0_clk _026_ VGND VGND VPWR VPWR memory\[4\]\[10\] sky130_fd_sc_hd__dfxtp_1
XTAP_TAPCELL_ROW_23_174 VGND VPWR sky130_fd_sc_hd__tapvpwrvgnd_1
X_430_ net19 net204 net44 VGND VGND VPWR VPWR _072_ sky130_fd_sc_hd__mux2_1
X_292_ memory\[0\]\[9\] memory\[1\]\[9\] net69 VGND VGND VPWR VPWR _205_ sky130_fd_sc_hd__mux2_1
X_361_ net142 net18 net52 VGND VGND VPWR VPWR _007_ sky130_fd_sc_hd__mux2_1
XFILLER_36_227 VGND VGND VPWR VPWR sky130_fd_sc_hd__fill_1
X_559_ clknet_4_1_0_clk _009_ VGND VGND VPWR VPWR memory\[5\]\[9\] sky130_fd_sc_hd__dfxtp_1
XTAP_TAPCELL_ROW_14_141 VGND VPWR sky130_fd_sc_hd__tapvpwrvgnd_1
X_628_ clknet_4_0_0_clk _078_ VGND VGND VPWR VPWR memory\[0\]\[14\] sky130_fd_sc_hd__dfxtp_1
XTAP_TAPCELL_ROW_6_109 VGND VPWR sky130_fd_sc_hd__tapvpwrvgnd_1
XTAP_TAPCELL_ROW_37_233 VGND VPWR sky130_fd_sc_hd__tapvpwrvgnd_1
XFILLER_12_78 VGND VGND VPWR VPWR sky130_fd_sc_hd__decap_6
X_344_ memory\[2\]\[15\] memory\[3\]\[15\] net76 VGND VGND VPWR VPWR _251_ sky130_fd_sc_hd__mux2_1
X_413_ net119 net19 net47 VGND VGND VPWR VPWR _056_ sky130_fd_sc_hd__mux2_1
X_275_ net60 _189_ VGND VGND VPWR VPWR _190_ sky130_fd_sc_hd__and2_1
XTAP_TAPCELL_ROW_31_206 VGND VPWR sky130_fd_sc_hd__tapvpwrvgnd_1
XFILLER_23_55 VGND VGND VPWR VPWR sky130_fd_sc_hd__fill_1
XFILLER_0_15 VPWR VGND VPWR VGND sky130_ef_sc_hd__decap_12
XFILLER_2_178 VPWR VGND VPWR VGND sky130_ef_sc_hd__decap_12
XFILLER_3_3 VPWR VGND VPWR VGND sky130_ef_sc_hd__decap_12
XFILLER_36_3 VPWR VGND VPWR VGND sky130_ef_sc_hd__decap_12
X_327_ memory\[0\]\[13\] memory\[1\]\[13\] net77 VGND VGND VPWR VPWR _236_ sky130_fd_sc_hd__mux2_1
XTAP_TAPCELL_ROW_0_80 VGND VPWR sky130_fd_sc_hd__tapvpwrvgnd_1
XFILLER_9_57 VGND VGND VPWR VPWR sky130_fd_sc_hd__decap_4
Xhold43 memory\[1\]\[3\] VGND VGND VPWR VPWR net121 sky130_fd_sc_hd__dlygate4sd3_1
Xhold10 memory\[2\]\[15\] VGND VGND VPWR VPWR net88 sky130_fd_sc_hd__dlygate4sd3_1
Xhold87 memory\[0\]\[0\] VGND VGND VPWR VPWR net165 sky130_fd_sc_hd__dlygate4sd3_1
Xhold65 memory\[1\]\[4\] VGND VGND VPWR VPWR net143 sky130_fd_sc_hd__dlygate4sd3_1
Xhold54 memory\[4\]\[12\] VGND VGND VPWR VPWR net132 sky130_fd_sc_hd__dlygate4sd3_1
XFILLER_29_54 VGND VGND VPWR VPWR sky130_fd_sc_hd__fill_2
XFILLER_29_21 VGND VGND VPWR VPWR sky130_fd_sc_hd__fill_1
XFILLER_28_152 VGND VGND VPWR VPWR sky130_fd_sc_hd__decap_6
X_661_ clknet_4_13_0_clk _111_ VGND VGND VPWR VPWR memory\[1\]\[15\] sky130_fd_sc_hd__dfxtp_1
X_592_ clknet_4_14_0_clk _042_ VGND VGND VPWR VPWR memory\[3\]\[10\] sky130_fd_sc_hd__dfxtp_1
Xhold32 memory\[5\]\[1\] VGND VGND VPWR VPWR net110 sky130_fd_sc_hd__dlygate4sd3_1
Xhold21 memory\[3\]\[8\] VGND VGND VPWR VPWR net99 sky130_fd_sc_hd__dlygate4sd3_1
Xhold98 memory\[3\]\[1\] VGND VGND VPWR VPWR net176 sky130_fd_sc_hd__dlygate4sd3_1
Xhold76 memory\[3\]\[2\] VGND VGND VPWR VPWR net154 sky130_fd_sc_hd__dlygate4sd3_1
Xoutput22 net22 VGND VGND VPWR VPWR mem_read_data[0] sky130_fd_sc_hd__buf_2
XFILLER_25_166 VGND VGND VPWR VPWR sky130_fd_sc_hd__fill_2
Xoutput33 net33 VGND VGND VPWR VPWR mem_read_data[5] sky130_fd_sc_hd__buf_2
X_575_ clknet_4_1_0_clk _025_ VGND VGND VPWR VPWR memory\[4\]\[9\] sky130_fd_sc_hd__dfxtp_1
Xclkbuf_4_10_0_clk clknet_0_clk VGND VGND VPWR VPWR clknet_4_10_0_clk sky130_fd_sc_hd__clkbuf_8
XFILLER_0_221 VGND VGND VPWR VPWR sky130_fd_sc_hd__decap_3
X_644_ clknet_4_2_0_clk _094_ VGND VGND VPWR VPWR memory\[6\]\[14\] sky130_fd_sc_hd__dfxtp_1
XFILLER_31_125 VGND VGND VPWR VPWR sky130_fd_sc_hd__decap_8
XFILLER_22_114 VGND VGND VPWR VPWR sky130_fd_sc_hd__fill_1
XTAP_TAPCELL_ROW_17_150 VGND VPWR sky130_fd_sc_hd__tapvpwrvgnd_1
XFILLER_26_66 VGND VGND VPWR VPWR sky130_fd_sc_hd__fill_2
XTAP_TAPCELL_ROW_23_175 VGND VPWR sky130_fd_sc_hd__tapvpwrvgnd_1
X_291_ _199_ _202_ _203_ _204_ VGND VGND VPWR VPWR net36 sky130_fd_sc_hd__o31a_1
X_360_ net124 net17 net53 VGND VGND VPWR VPWR _006_ sky130_fd_sc_hd__mux2_1
XTAP_TAPCELL_ROW_9_118 VGND VPWR sky130_fd_sc_hd__tapvpwrvgnd_1
XFILLER_9_129 VGND VGND VPWR VPWR sky130_fd_sc_hd__decap_6
X_627_ clknet_4_14_0_clk _077_ VGND VGND VPWR VPWR memory\[0\]\[13\] sky130_fd_sc_hd__dfxtp_1
X_558_ clknet_4_12_0_clk _008_ VGND VGND VPWR VPWR memory\[5\]\[8\] sky130_fd_sc_hd__dfxtp_1
X_489_ net66 VGND VGND VPWR VPWR _128_ sky130_fd_sc_hd__inv_2
XFILLER_3_15 VPWR VGND VPWR VGND sky130_ef_sc_hd__decap_12
X_274_ memory\[4\]\[7\] memory\[5\]\[7\] net70 VGND VGND VPWR VPWR _189_ sky130_fd_sc_hd__mux2_1
X_343_ _245_ _248_ _249_ _250_ VGND VGND VPWR VPWR net27 sky130_fd_sc_hd__o31a_1
X_412_ net79 net18 net46 VGND VGND VPWR VPWR _055_ sky130_fd_sc_hd__mux2_1
XFILLER_4_91 VGND VGND VPWR VPWR sky130_fd_sc_hd__fill_1
XFILLER_0_27 VGND VGND VPWR VPWR sky130_fd_sc_hd__fill_1
XTAP_TAPCELL_ROW_31_207 VGND VPWR sky130_fd_sc_hd__tapvpwrvgnd_1
XFILLER_29_3 VGND VGND VPWR VPWR sky130_fd_sc_hd__fill_2
X_326_ memory\[6\]\[13\] memory\[7\]\[13\] net77 VGND VGND VPWR VPWR _235_ sky130_fd_sc_hd__mux2_1
XTAP_TAPCELL_ROW_0_81 VGND VPWR sky130_fd_sc_hd__tapvpwrvgnd_1
X_309_ memory\[6\]\[11\] memory\[7\]\[11\] net69 VGND VGND VPWR VPWR _220_ sky130_fd_sc_hd__mux2_1
Xhold11 memory\[6\]\[0\] VGND VGND VPWR VPWR net89 sky130_fd_sc_hd__dlygate4sd3_1
Xhold33 memory\[5\]\[0\] VGND VGND VPWR VPWR net111 sky130_fd_sc_hd__dlygate4sd3_1
Xhold66 memory\[3\]\[12\] VGND VGND VPWR VPWR net144 sky130_fd_sc_hd__dlygate4sd3_1
Xhold88 memory\[1\]\[13\] VGND VGND VPWR VPWR net166 sky130_fd_sc_hd__dlygate4sd3_1
Xhold55 memory\[7\]\[8\] VGND VGND VPWR VPWR net133 sky130_fd_sc_hd__dlygate4sd3_1
X_591_ clknet_4_1_0_clk _041_ VGND VGND VPWR VPWR memory\[3\]\[9\] sky130_fd_sc_hd__dfxtp_1
Xhold77 memory\[7\]\[2\] VGND VGND VPWR VPWR net155 sky130_fd_sc_hd__dlygate4sd3_1
Xhold99 memory\[7\]\[6\] VGND VGND VPWR VPWR net177 sky130_fd_sc_hd__dlygate4sd3_1
XFILLER_6_15 VPWR VGND VPWR VGND sky130_ef_sc_hd__decap_12
Xhold22 memory\[1\]\[14\] VGND VGND VPWR VPWR net100 sky130_fd_sc_hd__dlygate4sd3_1
Xhold44 memory\[5\]\[11\] VGND VGND VPWR VPWR net122 sky130_fd_sc_hd__dlygate4sd3_1
X_660_ clknet_4_0_0_clk _110_ VGND VGND VPWR VPWR memory\[1\]\[14\] sky130_fd_sc_hd__dfxtp_1
XFILLER_19_153 VGND VGND VPWR VPWR sky130_fd_sc_hd__decap_4
Xoutput23 net23 VGND VGND VPWR VPWR mem_read_data[10] sky130_fd_sc_hd__buf_2
XFILLER_25_123 VGND VGND VPWR VPWR sky130_fd_sc_hd__fill_2
XFILLER_25_101 VGND VGND VPWR VPWR sky130_fd_sc_hd__fill_2
XFILLER_15_57 VGND VGND VPWR VPWR sky130_fd_sc_hd__decap_4
Xoutput34 net34 VGND VGND VPWR VPWR mem_read_data[6] sky130_fd_sc_hd__buf_2
X_643_ clknet_4_14_0_clk _093_ VGND VGND VPWR VPWR memory\[6\]\[13\] sky130_fd_sc_hd__dfxtp_1
X_574_ clknet_4_12_0_clk _024_ VGND VGND VPWR VPWR memory\[4\]\[8\] sky130_fd_sc_hd__dfxtp_1
XTAP_TAPCELL_ROW_17_151 VGND VPWR sky130_fd_sc_hd__tapvpwrvgnd_1
XTAP_TAPCELL_ROW_9_119 VGND VPWR sky130_fd_sc_hd__tapvpwrvgnd_1
X_488_ net97 net11 net39 VGND VGND VPWR VPWR _127_ sky130_fd_sc_hd__mux2_1
X_626_ clknet_4_6_0_clk _076_ VGND VGND VPWR VPWR memory\[0\]\[12\] sky130_fd_sc_hd__dfxtp_1
XTAP_TAPCELL_ROW_23_176 VGND VPWR sky130_fd_sc_hd__tapvpwrvgnd_1
X_290_ net63 net19 net64 VGND VGND VPWR VPWR _204_ sky130_fd_sc_hd__o21a_1
XFILLER_13_126 VGND VGND VPWR VPWR sky130_fd_sc_hd__decap_3
X_557_ clknet_4_1_0_clk _007_ VGND VGND VPWR VPWR memory\[5\]\[7\] sky130_fd_sc_hd__dfxtp_1
XFILLER_3_27 VGND VGND VPWR VPWR sky130_fd_sc_hd__fill_1
XFILLER_10_129 VGND VGND VPWR VPWR sky130_fd_sc_hd__fill_2
XFILLER_8_174 VGND VGND VPWR VPWR sky130_fd_sc_hd__fill_2
XFILLER_37_55 VGND VGND VPWR VPWR sky130_fd_sc_hd__fill_1
X_342_ net62 net10 net64 VGND VGND VPWR VPWR _250_ sky130_fd_sc_hd__o21a_1
XFILLER_5_111 VGND VGND VPWR VPWR sky130_fd_sc_hd__fill_1
XFILLER_5_122 VGND VGND VPWR VPWR sky130_fd_sc_hd__decap_8
X_273_ _182_ _186_ _187_ _188_ VGND VGND VPWR VPWR net34 sky130_fd_sc_hd__o31a_1
X_411_ net179 net17 net47 VGND VGND VPWR VPWR _054_ sky130_fd_sc_hd__mux2_1
X_609_ clknet_4_8_0_clk _059_ VGND VGND VPWR VPWR memory\[2\]\[11\] sky130_fd_sc_hd__dfxtp_1
XFILLER_23_57 VGND VGND VPWR VPWR sky130_fd_sc_hd__decap_6
XTAP_TAPCELL_ROW_31_208 VGND VPWR sky130_fd_sc_hd__tapvpwrvgnd_1
X_325_ _229_ _232_ _233_ _234_ VGND VGND VPWR VPWR net25 sky130_fd_sc_hd__o31a_1
XTAP_TAPCELL_ROW_0_82 VGND VPWR sky130_fd_sc_hd__tapvpwrvgnd_1
XPHY_EDGE_ROW_28_Left_67 VGND VGND VPWR VPWR sky130_fd_sc_hd__decap_3
Xclkload0 clknet_4_0_0_clk VGND VGND VPWR VPWR clkload0/Y sky130_fd_sc_hd__clkinv_2
X_308_ memory\[4\]\[11\] memory\[5\]\[11\] net69 VGND VGND VPWR VPWR _219_ sky130_fd_sc_hd__mux2_1
Xhold45 memory\[3\]\[0\] VGND VGND VPWR VPWR net123 sky130_fd_sc_hd__dlygate4sd3_1
XFILLER_28_176 VGND VGND VPWR VPWR sky130_fd_sc_hd__decap_6
Xhold12 memory\[4\]\[15\] VGND VGND VPWR VPWR net90 sky130_fd_sc_hd__dlygate4sd3_1
Xhold56 memory\[4\]\[0\] VGND VGND VPWR VPWR net134 sky130_fd_sc_hd__dlygate4sd3_1
Xhold34 memory\[2\]\[13\] VGND VGND VPWR VPWR net112 sky130_fd_sc_hd__dlygate4sd3_1
Xhold23 memory\[4\]\[13\] VGND VGND VPWR VPWR net101 sky130_fd_sc_hd__dlygate4sd3_1
Xhold67 memory\[2\]\[1\] VGND VGND VPWR VPWR net145 sky130_fd_sc_hd__dlygate4sd3_1
X_590_ clknet_4_9_0_clk _040_ VGND VGND VPWR VPWR memory\[3\]\[8\] sky130_fd_sc_hd__dfxtp_1
Xhold78 memory\[6\]\[9\] VGND VGND VPWR VPWR net156 sky130_fd_sc_hd__dlygate4sd3_1
Xhold89 memory\[1\]\[11\] VGND VGND VPWR VPWR net167 sky130_fd_sc_hd__dlygate4sd3_1
XFILLER_6_27 VGND VGND VPWR VPWR sky130_fd_sc_hd__fill_1
XFILLER_25_113 VGND VGND VPWR VPWR sky130_fd_sc_hd__fill_2
Xoutput35 net35 VGND VGND VPWR VPWR mem_read_data[7] sky130_fd_sc_hd__buf_2
Xoutput24 net24 VGND VGND VPWR VPWR mem_read_data[11] sky130_fd_sc_hd__buf_2
XPHY_EDGE_ROW_28_Right_28 VGND VGND VPWR VPWR sky130_fd_sc_hd__decap_3
X_642_ clknet_4_7_0_clk _092_ VGND VGND VPWR VPWR memory\[6\]\[12\] sky130_fd_sc_hd__dfxtp_1
XPHY_EDGE_ROW_19_Right_19 VGND VGND VPWR VPWR sky130_fd_sc_hd__decap_3
X_573_ clknet_4_1_0_clk _023_ VGND VGND VPWR VPWR memory\[4\]\[7\] sky130_fd_sc_hd__dfxtp_1
XPHY_EDGE_ROW_37_Right_37 VGND VGND VPWR VPWR sky130_fd_sc_hd__decap_3
XTAP_TAPCELL_ROW_17_152 VGND VPWR sky130_fd_sc_hd__tapvpwrvgnd_1
XPHY_EDGE_ROW_15_Left_54 VGND VGND VPWR VPWR sky130_fd_sc_hd__decap_3
XTAP_TAPCELL_ROW_23_177 VGND VPWR sky130_fd_sc_hd__tapvpwrvgnd_1
X_625_ clknet_4_3_0_clk _075_ VGND VGND VPWR VPWR memory\[0\]\[11\] sky130_fd_sc_hd__dfxtp_1
XFILLER_27_219 VGND VGND VPWR VPWR sky130_fd_sc_hd__decap_4
X_487_ net146 net10 net38 VGND VGND VPWR VPWR _126_ sky130_fd_sc_hd__mux2_1
X_556_ clknet_4_8_0_clk _006_ VGND VGND VPWR VPWR memory\[5\]\[6\] sky130_fd_sc_hd__dfxtp_1
Xhold120 memory\[5\]\[15\] VGND VGND VPWR VPWR net198 sky130_fd_sc_hd__dlygate4sd3_1
X_410_ net127 net16 net46 VGND VGND VPWR VPWR _053_ sky130_fd_sc_hd__mux2_1
XFILLER_12_26 VGND VGND VPWR VPWR sky130_fd_sc_hd__fill_2
XPHY_EDGE_ROW_0_Left_39 VGND VGND VPWR VPWR sky130_fd_sc_hd__decap_3
X_341_ net56 _246_ net66 VGND VGND VPWR VPWR _249_ sky130_fd_sc_hd__a21o_1
X_272_ net62 net17 net64 VGND VGND VPWR VPWR _188_ sky130_fd_sc_hd__o21a_1
X_608_ clknet_4_14_0_clk _058_ VGND VGND VPWR VPWR memory\[2\]\[10\] sky130_fd_sc_hd__dfxtp_1
X_539_ memory\[2\]\[5\] memory\[3\]\[5\] net71 VGND VGND VPWR VPWR _173_ sky130_fd_sc_hd__mux2_1
XFILLER_5_167 VGND VGND VPWR VPWR sky130_fd_sc_hd__fill_1
XFILLER_23_36 VGND VGND VPWR VPWR sky130_fd_sc_hd__fill_1
XTAP_TAPCELL_ROW_31_209 VGND VPWR sky130_fd_sc_hd__tapvpwrvgnd_1
X_324_ net62 net8 net64 VGND VGND VPWR VPWR _234_ sky130_fd_sc_hd__o21a_1
Xfanout70 net73 VGND VGND VPWR VPWR net70 sky130_fd_sc_hd__clkbuf_4
XFILLER_0_29 VGND VGND VPWR VPWR sky130_fd_sc_hd__fill_2
XFILLER_1_181 VGND VGND VPWR VPWR sky130_fd_sc_hd__decap_8
XTAP_TAPCELL_ROW_0_83 VGND VPWR sky130_fd_sc_hd__tapvpwrvgnd_1
Xclkload1 clknet_4_1_0_clk VGND VGND VPWR VPWR clkload1/Y sky130_fd_sc_hd__clkinv_2
XFILLER_11_225 VGND VGND VPWR VPWR sky130_fd_sc_hd__decap_3
XFILLER_1_3 VPWR VGND VPWR VGND sky130_ef_sc_hd__decap_12
XPHY_EDGE_ROW_3_Left_42 VGND VGND VPWR VPWR sky130_fd_sc_hd__decap_3
XFILLER_37_111 VGND VGND VPWR VPWR sky130_fd_sc_hd__fill_1
XFILLER_34_3 VGND VGND VPWR VPWR sky130_fd_sc_hd__decap_8
X_307_ net63 net6 _217_ _218_ net65 VGND VGND VPWR VPWR net23 sky130_fd_sc_hd__o221a_1
XFILLER_1_83 VGND VGND VPWR VPWR sky130_fd_sc_hd__decap_4
Xhold24 memory\[2\]\[4\] VGND VGND VPWR VPWR net102 sky130_fd_sc_hd__dlygate4sd3_1
XFILLER_29_57 VGND VGND VPWR VPWR sky130_fd_sc_hd__decap_3
Xhold35 memory\[6\]\[12\] VGND VGND VPWR VPWR net113 sky130_fd_sc_hd__dlygate4sd3_1
Xhold13 memory\[4\]\[5\] VGND VGND VPWR VPWR net91 sky130_fd_sc_hd__dlygate4sd3_1
XFILLER_20_37 VGND VGND VPWR VPWR sky130_fd_sc_hd__decap_3
Xhold79 memory\[6\]\[7\] VGND VGND VPWR VPWR net157 sky130_fd_sc_hd__dlygate4sd3_1
Xhold68 memory\[7\]\[14\] VGND VGND VPWR VPWR net146 sky130_fd_sc_hd__dlygate4sd3_1
Xhold57 memory\[7\]\[11\] VGND VGND VPWR VPWR net135 sky130_fd_sc_hd__dlygate4sd3_1
Xhold46 memory\[5\]\[6\] VGND VGND VPWR VPWR net124 sky130_fd_sc_hd__dlygate4sd3_1
XFILLER_34_158 VPWR VGND VPWR VGND sky130_ef_sc_hd__decap_12
XFILLER_19_166 VGND VGND VPWR VPWR sky130_fd_sc_hd__fill_2
XFILLER_25_158 VGND VGND VPWR VPWR sky130_fd_sc_hd__decap_8
XFILLER_15_37 VPWR VGND VPWR VGND sky130_ef_sc_hd__decap_12
XTAP_TAPCELL_ROW_26_186 VGND VPWR sky130_fd_sc_hd__tapvpwrvgnd_1
Xoutput25 net25 VGND VGND VPWR VPWR mem_read_data[12] sky130_fd_sc_hd__buf_2
Xoutput36 net36 VGND VGND VPWR VPWR mem_read_data[8] sky130_fd_sc_hd__buf_2
X_641_ clknet_4_2_0_clk _091_ VGND VGND VPWR VPWR memory\[6\]\[11\] sky130_fd_sc_hd__dfxtp_1
X_572_ clknet_4_10_0_clk _022_ VGND VGND VPWR VPWR memory\[4\]\[6\] sky130_fd_sc_hd__dfxtp_1
XFILLER_22_106 VGND VGND VPWR VPWR sky130_fd_sc_hd__decap_8
XTAP_TAPCELL_ROW_17_153 VGND VPWR sky130_fd_sc_hd__tapvpwrvgnd_1
XPHY_EDGE_ROW_32_Left_71 VGND VGND VPWR VPWR sky130_fd_sc_hd__decap_3
XFILLER_27_209 VGND VGND VPWR VPWR sky130_fd_sc_hd__fill_1
X_624_ clknet_4_15_0_clk _074_ VGND VGND VPWR VPWR memory\[0\]\[10\] sky130_fd_sc_hd__dfxtp_1
X_486_ net139 net9 net39 VGND VGND VPWR VPWR _125_ sky130_fd_sc_hd__mux2_1
X_555_ clknet_4_4_0_clk _005_ VGND VGND VPWR VPWR memory\[5\]\[5\] sky130_fd_sc_hd__dfxtp_1
XTAP_TAPCELL_ROW_3_94 VGND VPWR sky130_fd_sc_hd__tapvpwrvgnd_1
XFILLER_37_57 VPWR VGND VPWR VGND sky130_ef_sc_hd__decap_12
Xhold121 memory\[5\]\[4\] VGND VGND VPWR VPWR net199 sky130_fd_sc_hd__dlygate4sd3_1
Xhold110 memory\[0\]\[1\] VGND VGND VPWR VPWR net188 sky130_fd_sc_hd__dlygate4sd3_1
XTAP_TAPCELL_ROW_5_102 VGND VPWR sky130_fd_sc_hd__tapvpwrvgnd_1
XTAP_TAPCELL_ROW_34_218 VGND VPWR sky130_fd_sc_hd__tapvpwrvgnd_1
X_538_ _166_ _170_ _171_ _172_ VGND VGND VPWR VPWR net32 sky130_fd_sc_hd__o31a_1
X_607_ clknet_4_1_0_clk _057_ VGND VGND VPWR VPWR memory\[2\]\[9\] sky130_fd_sc_hd__dfxtp_1
XTAP_TAPCELL_ROW_11_126 VGND VPWR sky130_fd_sc_hd__tapvpwrvgnd_1
X_271_ net61 _183_ _185_ net58 VGND VGND VPWR VPWR _187_ sky130_fd_sc_hd__a22o_1
X_340_ net60 _243_ _247_ net54 VGND VGND VPWR VPWR _248_ sky130_fd_sc_hd__a22o_1
X_469_ net166 net9 net40 VGND VGND VPWR VPWR _109_ sky130_fd_sc_hd__mux2_1
XFILLER_23_15 VGND VGND VPWR VPWR sky130_fd_sc_hd__decap_4
XFILLER_4_83 VGND VGND VPWR VPWR sky130_fd_sc_hd__fill_1
Xfanout71 net73 VGND VGND VPWR VPWR net71 sky130_fd_sc_hd__clkbuf_4
X_323_ net58 _230_ net67 VGND VGND VPWR VPWR _233_ sky130_fd_sc_hd__a21o_1
Xfanout60 _129_ VGND VGND VPWR VPWR net60 sky130_fd_sc_hd__buf_2
XTAP_TAPCELL_ROW_0_84 VGND VPWR sky130_fd_sc_hd__tapvpwrvgnd_1
XFILLER_1_160 VGND VGND VPWR VPWR sky130_fd_sc_hd__decap_8
Xclkload2 clknet_4_2_0_clk VGND VGND VPWR VPWR clkload2/X sky130_fd_sc_hd__clkbuf_8
X_306_ net55 _213_ _216_ net57 net67 VGND VGND VPWR VPWR _218_ sky130_fd_sc_hd__a221o_1
XFILLER_37_167 VGND VGND VPWR VPWR sky130_fd_sc_hd__fill_1
Xhold69 memory\[2\]\[3\] VGND VGND VPWR VPWR net147 sky130_fd_sc_hd__dlygate4sd3_1
Xhold36 memory\[3\]\[5\] VGND VGND VPWR VPWR net114 sky130_fd_sc_hd__dlygate4sd3_1
Xhold25 memory\[6\]\[13\] VGND VGND VPWR VPWR net103 sky130_fd_sc_hd__dlygate4sd3_1
Xhold47 memory\[5\]\[13\] VGND VGND VPWR VPWR net125 sky130_fd_sc_hd__dlygate4sd3_1
Xhold58 memory\[1\]\[7\] VGND VGND VPWR VPWR net136 sky130_fd_sc_hd__dlygate4sd3_1
XFILLER_1_73 VGND VGND VPWR VPWR sky130_fd_sc_hd__fill_2
XFILLER_1_51 VGND VGND VPWR VPWR sky130_fd_sc_hd__decap_4
Xhold14 memory\[4\]\[2\] VGND VGND VPWR VPWR net92 sky130_fd_sc_hd__dlygate4sd3_1
XFILLER_10_82 VGND VGND VPWR VPWR sky130_fd_sc_hd__fill_2
XFILLER_6_29 VGND VGND VPWR VPWR sky130_fd_sc_hd__decap_4
XFILLER_31_107 VGND VGND VPWR VPWR sky130_fd_sc_hd__decap_4
X_640_ clknet_4_13_0_clk _090_ VGND VGND VPWR VPWR memory\[6\]\[10\] sky130_fd_sc_hd__dfxtp_1
XTAP_TAPCELL_ROW_26_187 VGND VPWR sky130_fd_sc_hd__tapvpwrvgnd_1
Xoutput26 net26 VGND VGND VPWR VPWR mem_read_data[13] sky130_fd_sc_hd__buf_2
X_571_ clknet_4_4_0_clk _021_ VGND VGND VPWR VPWR memory\[4\]\[5\] sky130_fd_sc_hd__dfxtp_1
Xoutput37 net37 VGND VGND VPWR VPWR mem_read_data[9] sky130_fd_sc_hd__buf_2
XPHY_EDGE_ROW_1_Right_1 VGND VGND VPWR VPWR sky130_fd_sc_hd__decap_3
XFILLER_0_225 VGND VGND VPWR VPWR sky130_fd_sc_hd__decap_3
XFILLER_30_195 VGND VGND VPWR VPWR sky130_fd_sc_hd__fill_1
XFILLER_13_118 VGND VGND VPWR VPWR sky130_fd_sc_hd__decap_8
X_554_ clknet_4_5_0_clk _004_ VGND VGND VPWR VPWR memory\[5\]\[4\] sky130_fd_sc_hd__dfxtp_1
X_485_ net196 net8 net39 VGND VGND VPWR VPWR _124_ sky130_fd_sc_hd__mux2_1
X_623_ clknet_4_3_0_clk _073_ VGND VGND VPWR VPWR memory\[0\]\[9\] sky130_fd_sc_hd__dfxtp_1
XTAP_TAPCELL_ROW_3_95 VGND VPWR sky130_fd_sc_hd__tapvpwrvgnd_1
Xhold111 memory\[0\]\[15\] VGND VGND VPWR VPWR net189 sky130_fd_sc_hd__dlygate4sd3_1
Xhold122 memory\[7\]\[10\] VGND VGND VPWR VPWR net200 sky130_fd_sc_hd__dlygate4sd3_1
Xhold100 memory\[1\]\[1\] VGND VGND VPWR VPWR net178 sky130_fd_sc_hd__dlygate4sd3_1
XTAP_TAPCELL_ROW_5_103 VGND VPWR sky130_fd_sc_hd__tapvpwrvgnd_1
XFILLER_37_69 VPWR VGND VPWR VGND sky130_ef_sc_hd__decap_12
XTAP_TAPCELL_ROW_11_127 VGND VPWR sky130_fd_sc_hd__tapvpwrvgnd_1
XFILLER_5_103 VGND VGND VPWR VPWR sky130_fd_sc_hd__fill_2
XFILLER_5_169 VGND VGND VPWR VPWR sky130_fd_sc_hd__fill_1
X_270_ net54 _184_ net67 VGND VGND VPWR VPWR _186_ sky130_fd_sc_hd__a21o_1
XTAP_TAPCELL_ROW_34_219 VGND VPWR sky130_fd_sc_hd__tapvpwrvgnd_1
X_537_ net62 net15 net64 VGND VGND VPWR VPWR _172_ sky130_fd_sc_hd__o21a_1
X_468_ net172 net8 net41 VGND VGND VPWR VPWR _108_ sky130_fd_sc_hd__mux2_1
X_606_ clknet_4_9_0_clk _056_ VGND VGND VPWR VPWR memory\[2\]\[8\] sky130_fd_sc_hd__dfxtp_1
X_399_ net160 net7 net48 VGND VGND VPWR VPWR _043_ sky130_fd_sc_hd__mux2_1
X_322_ net60 _227_ _231_ net56 VGND VGND VPWR VPWR _232_ sky130_fd_sc_hd__a22o_1
XFILLER_9_29 VGND VGND VPWR VPWR sky130_fd_sc_hd__fill_2
Xfanout72 net73 VGND VGND VPWR VPWR net72 sky130_fd_sc_hd__buf_2
Xfanout50 _260_ VGND VGND VPWR VPWR net50 sky130_fd_sc_hd__buf_4
XTAP_TAPCELL_ROW_0_85 VGND VPWR sky130_fd_sc_hd__tapvpwrvgnd_1
Xfanout61 _129_ VGND VGND VPWR VPWR net61 sky130_fd_sc_hd__buf_2
Xclkload3 clknet_4_4_0_clk VGND VGND VPWR VPWR clkload3/Y sky130_fd_sc_hd__bufinv_16
X_305_ net59 _214_ _215_ net61 VGND VGND VPWR VPWR _217_ sky130_fd_sc_hd__a22o_1
XFILLER_24_81 VGND VGND VPWR VPWR sky130_fd_sc_hd__decap_3
XFILLER_37_113 VPWR VGND VPWR VGND sky130_ef_sc_hd__decap_12
Xhold15 memory\[2\]\[10\] VGND VGND VPWR VPWR net93 sky130_fd_sc_hd__dlygate4sd3_1
XFILLER_19_113 VGND VGND VPWR VPWR sky130_fd_sc_hd__decap_6
Xhold48 memory\[5\]\[8\] VGND VGND VPWR VPWR net126 sky130_fd_sc_hd__dlygate4sd3_1
Xhold59 memory\[2\]\[11\] VGND VGND VPWR VPWR net137 sky130_fd_sc_hd__dlygate4sd3_1
XFILLER_10_61 VGND VGND VPWR VPWR sky130_fd_sc_hd__decap_4
XFILLER_10_50 VGND VGND VPWR VPWR sky130_fd_sc_hd__decap_3
Xhold37 memory\[6\]\[2\] VGND VGND VPWR VPWR net115 sky130_fd_sc_hd__dlygate4sd3_1
XFILLER_3_223 VGND VGND VPWR VPWR sky130_fd_sc_hd__fill_1
Xhold26 memory\[6\]\[6\] VGND VGND VPWR VPWR net104 sky130_fd_sc_hd__dlygate4sd3_1
XFILLER_19_157 VGND VGND VPWR VPWR sky130_fd_sc_hd__fill_1
X_570_ clknet_4_5_0_clk _020_ VGND VGND VPWR VPWR memory\[4\]\[4\] sky130_fd_sc_hd__dfxtp_1
XFILLER_16_138 VGND VGND VPWR VPWR sky130_fd_sc_hd__fill_2
XFILLER_16_116 VGND VGND VPWR VPWR sky130_fd_sc_hd__decap_4
Xoutput27 net27 VGND VGND VPWR VPWR mem_read_data[14] sky130_fd_sc_hd__buf_2
XTAP_TAPCELL_ROW_26_188 VGND VPWR sky130_fd_sc_hd__tapvpwrvgnd_1
XFILLER_24_193 VGND VGND VPWR VPWR sky130_fd_sc_hd__decap_3
Xclkbuf_0_clk clk VGND VGND VPWR VPWR clknet_0_clk sky130_fd_sc_hd__clkbuf_16
XFILLER_11_7 VGND VGND VPWR VPWR sky130_fd_sc_hd__decap_4
XPHY_EDGE_ROW_24_Right_24 VGND VGND VPWR VPWR sky130_fd_sc_hd__decap_3
XPHY_EDGE_ROW_15_Right_15 VGND VGND VPWR VPWR sky130_fd_sc_hd__decap_3
XPHY_EDGE_ROW_33_Right_33 VGND VGND VPWR VPWR sky130_fd_sc_hd__decap_3
X_553_ clknet_4_15_0_clk _003_ VGND VGND VPWR VPWR memory\[5\]\[3\] sky130_fd_sc_hd__dfxtp_1
X_622_ clknet_4_3_0_clk _072_ VGND VGND VPWR VPWR memory\[0\]\[8\] sky130_fd_sc_hd__dfxtp_1
XFILLER_12_174 VGND VGND VPWR VPWR sky130_fd_sc_hd__fill_1
X_484_ net135 net7 net38 VGND VGND VPWR VPWR _123_ sky130_fd_sc_hd__mux2_1
XPHY_EDGE_ROW_19_Left_58 VGND VGND VPWR VPWR sky130_fd_sc_hd__decap_3
XFILLER_12_29 VGND VGND VPWR VPWR sky130_fd_sc_hd__fill_1
Xhold123 memory\[0\]\[6\] VGND VGND VPWR VPWR net201 sky130_fd_sc_hd__dlygate4sd3_1
XTAP_TAPCELL_ROW_3_96 VGND VPWR sky130_fd_sc_hd__tapvpwrvgnd_1
Xhold101 memory\[2\]\[6\] VGND VGND VPWR VPWR net179 sky130_fd_sc_hd__dlygate4sd3_1
Xhold112 memory\[2\]\[14\] VGND VGND VPWR VPWR net190 sky130_fd_sc_hd__dlygate4sd3_1
XFILLER_37_15 VPWR VGND VPWR VGND sky130_ef_sc_hd__decap_12
XTAP_TAPCELL_ROW_11_128 VGND VPWR sky130_fd_sc_hd__tapvpwrvgnd_1
XTAP_TAPCELL_ROW_5_104 VGND VPWR sky130_fd_sc_hd__tapvpwrvgnd_1
X_536_ net55 _167_ _169_ net56 VGND VGND VPWR VPWR _171_ sky130_fd_sc_hd__a22o_1
X_398_ net175 net6 net49 VGND VGND VPWR VPWR _042_ sky130_fd_sc_hd__mux2_1
XFILLER_4_85 VGND VGND VPWR VPWR sky130_fd_sc_hd__decap_6
X_605_ clknet_4_0_0_clk _055_ VGND VGND VPWR VPWR memory\[2\]\[7\] sky130_fd_sc_hd__dfxtp_1
X_467_ net167 net7 net40 VGND VGND VPWR VPWR _107_ sky130_fd_sc_hd__mux2_1
XFILLER_23_225 VGND VGND VPWR VPWR sky130_fd_sc_hd__decap_3
XFILLER_23_28 VGND VGND VPWR VPWR sky130_fd_sc_hd__decap_8
XFILLER_2_129 VGND VGND VPWR VPWR sky130_fd_sc_hd__fill_2
Xfanout73 net78 VGND VGND VPWR VPWR net73 sky130_fd_sc_hd__clkbuf_2
X_321_ memory\[2\]\[12\] memory\[3\]\[12\] net71 VGND VGND VPWR VPWR _231_ sky130_fd_sc_hd__mux2_1
Xfanout51 _260_ VGND VGND VPWR VPWR net51 sky130_fd_sc_hd__buf_2
Xfanout40 _265_ VGND VGND VPWR VPWR net40 sky130_fd_sc_hd__buf_4
Xfanout62 _128_ VGND VGND VPWR VPWR net62 sky130_fd_sc_hd__clkbuf_4
XFILLER_13_94 VGND VGND VPWR VPWR sky130_fd_sc_hd__fill_1
XFILLER_34_27 VGND VGND VPWR VPWR sky130_fd_sc_hd__fill_1
Xclkload10 clknet_4_13_0_clk VGND VGND VPWR VPWR clkload10/X sky130_fd_sc_hd__clkbuf_8
XFILLER_11_206 VGND VGND VPWR VPWR sky130_fd_sc_hd__fill_2
X_519_ net63 net13 net65 VGND VGND VPWR VPWR _156_ sky130_fd_sc_hd__o21a_1
Xclkload4 clknet_4_5_0_clk VGND VGND VPWR VPWR clkload4/X sky130_fd_sc_hd__clkbuf_4
X_304_ memory\[2\]\[10\] memory\[3\]\[10\] net76 VGND VGND VPWR VPWR _216_ sky130_fd_sc_hd__mux2_1
XFILLER_37_169 VPWR VGND VPWR VGND sky130_ef_sc_hd__decap_12
XFILLER_37_125 VPWR VGND VPWR VGND sky130_ef_sc_hd__decap_12
Xhold16 memory\[6\]\[15\] VGND VGND VPWR VPWR net94 sky130_fd_sc_hd__dlygate4sd3_1
XFILLER_28_158 VGND VGND VPWR VPWR sky130_fd_sc_hd__fill_1
Xhold49 memory\[2\]\[5\] VGND VGND VPWR VPWR net127 sky130_fd_sc_hd__dlygate4sd3_1
Xhold27 memory\[6\]\[5\] VGND VGND VPWR VPWR net105 sky130_fd_sc_hd__dlygate4sd3_1
Xhold38 memory\[6\]\[1\] VGND VGND VPWR VPWR net116 sky130_fd_sc_hd__dlygate4sd3_1
XPHY_EDGE_ROW_7_Left_46 VGND VGND VPWR VPWR sky130_fd_sc_hd__decap_3
XFILLER_35_81 VGND VGND VPWR VPWR sky130_fd_sc_hd__decap_6
XFILLER_32_3 VPWR VGND VPWR VGND sky130_ef_sc_hd__decap_12
XFILLER_19_169 VGND VGND VPWR VPWR sky130_fd_sc_hd__decap_4
XFILLER_19_93 VGND VGND VPWR VPWR sky130_fd_sc_hd__fill_2
XFILLER_19_82 VGND VGND VPWR VPWR sky130_fd_sc_hd__fill_2
Xoutput28 net28 VGND VGND VPWR VPWR mem_read_data[15] sky130_fd_sc_hd__buf_2
XFILLER_31_28 VGND VGND VPWR VPWR sky130_fd_sc_hd__decap_4
XFILLER_18_191 VGND VGND VPWR VPWR sky130_fd_sc_hd__decap_4
XTAP_TAPCELL_ROW_26_189 VGND VPWR sky130_fd_sc_hd__tapvpwrvgnd_1
XFILLER_30_164 VGND VGND VPWR VPWR sky130_fd_sc_hd__decap_6
XFILLER_7_30 VGND VGND VPWR VPWR sky130_fd_sc_hd__fill_1
X_483_ net200 net6 net38 VGND VGND VPWR VPWR _122_ sky130_fd_sc_hd__mux2_1
XFILLER_21_164 VGND VGND VPWR VPWR sky130_fd_sc_hd__decap_4
X_621_ clknet_4_0_0_clk _071_ VGND VGND VPWR VPWR memory\[0\]\[7\] sky130_fd_sc_hd__dfxtp_1
X_552_ clknet_4_8_0_clk _002_ VGND VGND VPWR VPWR memory\[5\]\[2\] sky130_fd_sc_hd__dfxtp_1
XTAP_TAPCELL_ROW_22_170 VGND VPWR sky130_fd_sc_hd__tapvpwrvgnd_1
XTAP_TAPCELL_ROW_3_97 VGND VPWR sky130_fd_sc_hd__tapvpwrvgnd_1
XFILLER_37_27 VPWR VGND VPWR VGND sky130_ef_sc_hd__decap_12
Xhold102 memory\[0\]\[3\] VGND VGND VPWR VPWR net180 sky130_fd_sc_hd__dlygate4sd3_1
Xhold124 memory\[1\]\[15\] VGND VGND VPWR VPWR net202 sky130_fd_sc_hd__dlygate4sd3_1
XFILLER_26_223 VGND VGND VPWR VPWR sky130_fd_sc_hd__fill_1
XTAP_TAPCELL_ROW_11_129 VGND VPWR sky130_fd_sc_hd__tapvpwrvgnd_1
XTAP_TAPCELL_ROW_5_105 VGND VPWR sky130_fd_sc_hd__tapvpwrvgnd_1
Xhold113 memory\[0\]\[11\] VGND VGND VPWR VPWR net191 sky130_fd_sc_hd__dlygate4sd3_1
XPHY_EDGE_ROW_36_Left_75 VGND VGND VPWR VPWR sky130_fd_sc_hd__decap_3
X_535_ net59 _168_ net68 VGND VGND VPWR VPWR _170_ sky130_fd_sc_hd__a21o_1
X_466_ net186 net6 net41 VGND VGND VPWR VPWR _106_ sky130_fd_sc_hd__mux2_1
XFILLER_27_93 VGND VGND VPWR VPWR sky130_fd_sc_hd__decap_3
XPHY_EDGE_ROW_20_Left_59 VGND VGND VPWR VPWR sky130_fd_sc_hd__decap_3
XFILLER_17_223 VGND VGND VPWR VPWR sky130_fd_sc_hd__fill_1
X_397_ net130 net20 net48 VGND VGND VPWR VPWR _041_ sky130_fd_sc_hd__mux2_1
X_604_ clknet_4_10_0_clk _054_ VGND VGND VPWR VPWR memory\[2\]\[6\] sky130_fd_sc_hd__dfxtp_1
XFILLER_23_204 VGND VGND VPWR VPWR sky130_fd_sc_hd__decap_4
XFILLER_38_70 VPWR VGND VPWR VGND sky130_ef_sc_hd__decap_12
X_320_ memory\[6\]\[12\] memory\[7\]\[12\] net71 VGND VGND VPWR VPWR _230_ sky130_fd_sc_hd__mux2_1
Xfanout41 _265_ VGND VGND VPWR VPWR net41 sky130_fd_sc_hd__buf_2
Xfanout63 _128_ VGND VGND VPWR VPWR net63 sky130_fd_sc_hd__buf_2
Xfanout74 net78 VGND VGND VPWR VPWR net74 sky130_fd_sc_hd__clkbuf_4
XFILLER_13_84 VGND VGND VPWR VPWR sky130_fd_sc_hd__fill_1
XFILLER_13_51 VGND VGND VPWR VPWR sky130_fd_sc_hd__decap_4
Xfanout52 _259_ VGND VGND VPWR VPWR net52 sky130_fd_sc_hd__buf_4
XTAP_TAPCELL_ROW_30_202 VGND VPWR sky130_fd_sc_hd__tapvpwrvgnd_1
Xclkload11 clknet_4_14_0_clk VGND VGND VPWR VPWR clkload11/Y sky130_fd_sc_hd__clkinv_2
X_449_ net83 net6 net42 VGND VGND VPWR VPWR _090_ sky130_fd_sc_hd__mux2_1
XFILLER_20_218 VGND VGND VPWR VPWR sky130_fd_sc_hd__fill_2
X_518_ net57 _152_ net67 VGND VGND VPWR VPWR _155_ sky130_fd_sc_hd__a21o_1
Xclkload5 clknet_4_6_0_clk VGND VGND VPWR VPWR clkload5/X sky130_fd_sc_hd__clkbuf_8
XFILLER_37_137 VPWR VGND VPWR VGND sky130_ef_sc_hd__decap_12
X_303_ memory\[4\]\[10\] memory\[5\]\[10\] net76 VGND VGND VPWR VPWR _215_ sky130_fd_sc_hd__mux2_1
XPHY_EDGE_ROW_23_Left_62 VGND VGND VPWR VPWR sky130_fd_sc_hd__decap_3
Xhold17 memory\[6\]\[4\] VGND VGND VPWR VPWR net95 sky130_fd_sc_hd__dlygate4sd3_1
XFILLER_29_28 VGND VGND VPWR VPWR sky130_fd_sc_hd__fill_1
Xhold28 memory\[4\]\[9\] VGND VGND VPWR VPWR net106 sky130_fd_sc_hd__dlygate4sd3_1
Xhold39 memory\[5\]\[14\] VGND VGND VPWR VPWR net117 sky130_fd_sc_hd__dlygate4sd3_1
XFILLER_34_118 VGND VGND VPWR VPWR sky130_fd_sc_hd__decap_6
XTAP_TAPCELL_ROW_29_198 VGND VPWR sky130_fd_sc_hd__tapvpwrvgnd_1
XFILLER_3_225 VGND VGND VPWR VPWR sky130_fd_sc_hd__decap_3
Xoutput29 net29 VGND VGND VPWR VPWR mem_read_data[1] sky130_fd_sc_hd__buf_2
XFILLER_24_184 VGND VGND VPWR VPWR sky130_fd_sc_hd__fill_1
XFILLER_38_221 VGND VGND VPWR VPWR sky130_fd_sc_hd__decap_3
XFILLER_7_75 VGND VGND VPWR VPWR sky130_fd_sc_hd__decap_6
X_551_ clknet_4_9_0_clk _001_ VGND VGND VPWR VPWR memory\[5\]\[1\] sky130_fd_sc_hd__dfxtp_1
XPHY_EDGE_ROW_5_Right_5 VGND VGND VPWR VPWR sky130_fd_sc_hd__decap_3
X_620_ clknet_4_10_0_clk _070_ VGND VGND VPWR VPWR memory\[0\]\[6\] sky130_fd_sc_hd__dfxtp_1
XTAP_TAPCELL_ROW_8_114 VGND VPWR sky130_fd_sc_hd__tapvpwrvgnd_1
XTAP_TAPCELL_ROW_22_171 VGND VPWR sky130_fd_sc_hd__tapvpwrvgnd_1
X_482_ net129 net20 net38 VGND VGND VPWR VPWR _121_ sky130_fd_sc_hd__mux2_1
XTAP_TAPCELL_ROW_14_138 VGND VPWR sky130_fd_sc_hd__tapvpwrvgnd_1
XFILLER_12_110 VPWR VGND VPWR VGND sky130_ef_sc_hd__decap_12
XFILLER_37_39 VPWR VGND VPWR VGND sky130_ef_sc_hd__decap_12
Xhold114 memory\[0\]\[10\] VGND VGND VPWR VPWR net192 sky130_fd_sc_hd__dlygate4sd3_1
Xhold125 memory\[0\]\[2\] VGND VGND VPWR VPWR net203 sky130_fd_sc_hd__dlygate4sd3_1
Xhold103 memory\[1\]\[2\] VGND VGND VPWR VPWR net181 sky130_fd_sc_hd__dlygate4sd3_1
X_534_ memory\[2\]\[4\] memory\[3\]\[4\] net71 VGND VGND VPWR VPWR _169_ sky130_fd_sc_hd__mux2_1
X_603_ clknet_4_4_0_clk _053_ VGND VGND VPWR VPWR memory\[2\]\[5\] sky130_fd_sc_hd__dfxtp_1
X_465_ net140 net20 net40 VGND VGND VPWR VPWR _105_ sky130_fd_sc_hd__mux2_1
X_396_ net99 net19 net49 VGND VGND VPWR VPWR _040_ sky130_fd_sc_hd__mux2_1
XFILLER_23_19 VGND VGND VPWR VPWR sky130_fd_sc_hd__fill_1
Xfanout53 _259_ VGND VGND VPWR VPWR net53 sky130_fd_sc_hd__buf_2
Xfanout42 _264_ VGND VGND VPWR VPWR net42 sky130_fd_sc_hd__buf_4
Xfanout75 net78 VGND VGND VPWR VPWR net75 sky130_fd_sc_hd__clkbuf_2
Xfanout64 net4 VGND VGND VPWR VPWR net64 sky130_fd_sc_hd__clkbuf_4
XFILLER_38_93 VGND VGND VPWR VPWR sky130_fd_sc_hd__fill_1
XFILLER_38_82 VGND VGND VPWR VPWR sky130_fd_sc_hd__fill_2
XTAP_TAPCELL_ROW_30_203 VGND VPWR sky130_fd_sc_hd__tapvpwrvgnd_1
Xclkload12 clknet_4_15_0_clk VGND VGND VPWR VPWR clkload12/X sky130_fd_sc_hd__clkbuf_4
X_379_ net108 net19 net51 VGND VGND VPWR VPWR _024_ sky130_fd_sc_hd__mux2_1
X_448_ net156 net20 net42 VGND VGND VPWR VPWR _089_ sky130_fd_sc_hd__mux2_1
X_517_ net61 _149_ _153_ net54 VGND VGND VPWR VPWR _154_ sky130_fd_sc_hd__a22o_1
Xclkload6 clknet_4_8_0_clk VGND VGND VPWR VPWR clkload6/X sky130_fd_sc_hd__clkbuf_8
XFILLER_37_149 VPWR VGND VPWR VGND sky130_ef_sc_hd__decap_12
XFILLER_37_105 VGND VGND VPWR VPWR sky130_fd_sc_hd__decap_6
X_302_ memory\[6\]\[10\] memory\[7\]\[10\] net76 VGND VGND VPWR VPWR _214_ sky130_fd_sc_hd__mux2_1
XFILLER_27_7 VGND VGND VPWR VPWR sky130_fd_sc_hd__decap_3
XFILLER_24_40 VGND VGND VPWR VPWR sky130_fd_sc_hd__fill_1
XFILLER_1_55 VGND VGND VPWR VPWR sky130_fd_sc_hd__fill_1
XFILLER_28_138 VGND VGND VPWR VPWR sky130_fd_sc_hd__fill_2
Xhold18 memory\[5\]\[5\] VGND VGND VPWR VPWR net96 sky130_fd_sc_hd__dlygate4sd3_1
Xhold29 memory\[4\]\[1\] VGND VGND VPWR VPWR net107 sky130_fd_sc_hd__dlygate4sd3_1
XTAP_TAPCELL_ROW_29_199 VGND VPWR sky130_fd_sc_hd__tapvpwrvgnd_1
XFILLER_33_152 VGND VGND VPWR VPWR sky130_fd_sc_hd__decap_8
XFILLER_18_160 VGND VGND VPWR VPWR sky130_fd_sc_hd__decap_6
XFILLER_21_74 VGND VGND VPWR VPWR sky130_fd_sc_hd__fill_1
XTAP_TAPCELL_ROW_8_115 VGND VPWR sky130_fd_sc_hd__tapvpwrvgnd_1
XFILLER_29_222 VGND VGND VPWR VPWR sky130_fd_sc_hd__fill_2
X_550_ clknet_4_6_0_clk _000_ VGND VGND VPWR VPWR memory\[5\]\[0\] sky130_fd_sc_hd__dfxtp_1
XTAP_TAPCELL_ROW_22_172 VGND VPWR sky130_fd_sc_hd__tapvpwrvgnd_1
XPHY_EDGE_ROW_20_Right_20 VGND VGND VPWR VPWR sky130_fd_sc_hd__decap_3
X_481_ net133 net19 net38 VGND VGND VPWR VPWR _120_ sky130_fd_sc_hd__mux2_1
XTAP_TAPCELL_ROW_14_139 VGND VPWR sky130_fd_sc_hd__tapvpwrvgnd_1
XFILLER_12_122 VGND VGND VPWR VPWR sky130_fd_sc_hd__decap_8
XPHY_EDGE_ROW_11_Right_11 VGND VGND VPWR VPWR sky130_fd_sc_hd__decap_3
XFILLER_35_225 VGND VGND VPWR VPWR sky130_fd_sc_hd__decap_3
Xhold115 memory\[5\]\[12\] VGND VGND VPWR VPWR net193 sky130_fd_sc_hd__dlygate4sd3_1
Xhold126 memory\[0\]\[8\] VGND VGND VPWR VPWR net204 sky130_fd_sc_hd__dlygate4sd3_1
Xhold104 memory\[4\]\[7\] VGND VGND VPWR VPWR net182 sky130_fd_sc_hd__dlygate4sd3_1
X_602_ clknet_4_5_0_clk _052_ VGND VGND VPWR VPWR memory\[2\]\[4\] sky130_fd_sc_hd__dfxtp_1
X_533_ memory\[6\]\[4\] memory\[7\]\[4\] net72 VGND VGND VPWR VPWR _168_ sky130_fd_sc_hd__mux2_1
X_464_ net197 net19 net40 VGND VGND VPWR VPWR _104_ sky130_fd_sc_hd__mux2_1
XFILLER_17_225 VGND VGND VPWR VPWR sky130_fd_sc_hd__decap_3
XFILLER_23_217 VGND VGND VPWR VPWR sky130_fd_sc_hd__decap_3
X_395_ net173 net18 net48 VGND VGND VPWR VPWR _039_ sky130_fd_sc_hd__mux2_1
Xfanout76 net78 VGND VGND VPWR VPWR net76 sky130_fd_sc_hd__clkbuf_4
Xfanout43 _264_ VGND VGND VPWR VPWR net43 sky130_fd_sc_hd__buf_2
Xfanout65 net4 VGND VGND VPWR VPWR net65 sky130_fd_sc_hd__clkbuf_2
Xfanout54 _137_ VGND VGND VPWR VPWR net54 sky130_fd_sc_hd__clkbuf_4
XTAP_TAPCELL_ROW_30_204 VGND VPWR sky130_fd_sc_hd__tapvpwrvgnd_1
X_447_ net81 net19 net43 VGND VGND VPWR VPWR _088_ sky130_fd_sc_hd__mux2_1
X_378_ net182 net18 net50 VGND VGND VPWR VPWR _023_ sky130_fd_sc_hd__mux2_1
X_516_ memory\[0\]\[2\] memory\[1\]\[2\] net74 VGND VGND VPWR VPWR _153_ sky130_fd_sc_hd__mux2_1
XFILLER_1_121 VPWR VGND VPWR VGND sky130_ef_sc_hd__decap_12
XTAP_TAPCELL_ROW_0_78 VGND VPWR sky130_fd_sc_hd__tapvpwrvgnd_1
Xclkload7 clknet_4_9_0_clk VGND VGND VPWR VPWR clkload7/Y sky130_fd_sc_hd__clkinv_2
X_301_ memory\[0\]\[10\] memory\[1\]\[10\] net76 VGND VGND VPWR VPWR _213_ sky130_fd_sc_hd__mux2_1
XFILLER_24_96 VGND VGND VPWR VPWR sky130_fd_sc_hd__fill_1
Xhold19 memory\[7\]\[15\] VGND VGND VPWR VPWR net97 sky130_fd_sc_hd__dlygate4sd3_1
XFILLER_19_74 VGND VGND VPWR VPWR sky130_fd_sc_hd__decap_8
XFILLER_19_52 VGND VGND VPWR VPWR sky130_fd_sc_hd__decap_4
XFILLER_19_30 VGND VGND VPWR VPWR sky130_fd_sc_hd__fill_1
XFILLER_30_3 VGND VGND VPWR VPWR sky130_fd_sc_hd__decap_3
XTAP_TAPCELL_ROW_8_116 VGND VPWR sky130_fd_sc_hd__tapvpwrvgnd_1
XFILLER_32_63 VGND VGND VPWR VPWR sky130_fd_sc_hd__decap_4
XTAP_TAPCELL_ROW_22_173 VGND VPWR sky130_fd_sc_hd__tapvpwrvgnd_1
X_480_ net168 net18 net38 VGND VGND VPWR VPWR _119_ sky130_fd_sc_hd__mux2_1
XFILLER_8_127 VGND VGND VPWR VPWR sky130_fd_sc_hd__decap_6
Xhold105 memory\[0\]\[12\] VGND VGND VPWR VPWR net183 sky130_fd_sc_hd__dlygate4sd3_1
Xhold116 memory\[0\]\[5\] VGND VGND VPWR VPWR net194 sky130_fd_sc_hd__dlygate4sd3_1
Xhold127 memory\[0\]\[9\] VGND VGND VPWR VPWR net205 sky130_fd_sc_hd__dlygate4sd3_1
X_601_ clknet_4_15_0_clk _051_ VGND VGND VPWR VPWR memory\[2\]\[3\] sky130_fd_sc_hd__dfxtp_1
XFILLER_17_204 VGND VGND VPWR VPWR sky130_fd_sc_hd__decap_3
X_532_ memory\[0\]\[4\] memory\[1\]\[4\] net71 VGND VGND VPWR VPWR _167_ sky130_fd_sc_hd__mux2_1
X_463_ net136 net18 net40 VGND VGND VPWR VPWR _103_ sky130_fd_sc_hd__mux2_1
XFILLER_4_67 VPWR VGND VPWR VGND sky130_ef_sc_hd__decap_12
XFILLER_4_141 VGND VGND VPWR VPWR sky130_fd_sc_hd__fill_1
X_394_ net171 net17 net49 VGND VGND VPWR VPWR _038_ sky130_fd_sc_hd__mux2_1
Xfanout55 _137_ VGND VGND VPWR VPWR net55 sky130_fd_sc_hd__buf_2
Xfanout44 _263_ VGND VGND VPWR VPWR net44 sky130_fd_sc_hd__buf_4
Xfanout77 net78 VGND VGND VPWR VPWR net77 sky130_fd_sc_hd__buf_2
XTAP_TAPCELL_ROW_30_205 VGND VPWR sky130_fd_sc_hd__tapvpwrvgnd_1
X_446_ net157 net18 net42 VGND VGND VPWR VPWR _087_ sky130_fd_sc_hd__mux2_1
XFILLER_1_133 VGND VGND VPWR VPWR sky130_fd_sc_hd__decap_3
XFILLER_1_111 VGND VGND VPWR VPWR sky130_fd_sc_hd__fill_1
XTAP_TAPCELL_ROW_0_79 VGND VPWR sky130_fd_sc_hd__tapvpwrvgnd_1
X_377_ net120 net17 net51 VGND VGND VPWR VPWR _022_ sky130_fd_sc_hd__mux2_1
Xfanout66 net67 VGND VGND VPWR VPWR net66 sky130_fd_sc_hd__buf_2
X_515_ memory\[2\]\[2\] memory\[3\]\[2\] net74 VGND VGND VPWR VPWR _152_ sky130_fd_sc_hd__mux2_1
XFILLER_8_3 VGND VGND VPWR VPWR sky130_fd_sc_hd__fill_2
XFILLER_9_200 VGND VGND VPWR VPWR sky130_fd_sc_hd__decap_3
Xclkload8 clknet_4_11_0_clk VGND VGND VPWR VPWR clkload8/X sky130_fd_sc_hd__clkbuf_8
X_300_ _206_ _209_ _211_ _212_ net64 VGND VGND VPWR VPWR net37 sky130_fd_sc_hd__o311a_1
X_429_ net18 net170 net44 VGND VGND VPWR VPWR _071_ sky130_fd_sc_hd__mux2_1
XFILLER_36_195 VGND VGND VPWR VPWR sky130_fd_sc_hd__fill_1
Xinput1 mem_access_addr[1] VGND VGND VPWR VPWR net1 sky130_fd_sc_hd__clkbuf_1
XPHY_EDGE_ROW_27_Left_66 VGND VGND VPWR VPWR sky130_fd_sc_hd__decap_3
XFILLER_18_195 VGND VGND VPWR VPWR sky130_fd_sc_hd__fill_1
XFILLER_0_209 VPWR VGND VPWR VGND sky130_ef_sc_hd__decap_12
XFILLER_30_124 VGND VGND VPWR VPWR sky130_fd_sc_hd__fill_1
XTAP_TAPCELL_ROW_25_182 VGND VPWR sky130_fd_sc_hd__tapvpwrvgnd_1
XFILLER_24_176 VGND VGND VPWR VPWR sky130_fd_sc_hd__decap_8
XFILLER_23_3 VPWR VGND VPWR VGND sky130_ef_sc_hd__decap_12
XFILLER_21_113 VGND VGND VPWR VPWR sky130_fd_sc_hd__decap_4
XFILLER_7_23 VGND VGND VPWR VPWR sky130_fd_sc_hd__decap_3
XTAP_TAPCELL_ROW_8_117 VGND VPWR sky130_fd_sc_hd__tapvpwrvgnd_1
Xhold106 memory\[7\]\[3\] VGND VGND VPWR VPWR net184 sky130_fd_sc_hd__dlygate4sd3_1
Xhold117 memory\[1\]\[0\] VGND VGND VPWR VPWR net195 sky130_fd_sc_hd__dlygate4sd3_1
X_677_ clknet_4_13_0_clk _127_ VGND VGND VPWR VPWR memory\[7\]\[15\] sky130_fd_sc_hd__dfxtp_1
Xhold128 memory\[4\]\[4\] VGND VGND VPWR VPWR net206 sky130_fd_sc_hd__dlygate4sd3_1
XPHY_EDGE_ROW_9_Right_9 VGND VGND VPWR VPWR sky130_fd_sc_hd__decap_3
XPHY_EDGE_ROW_14_Left_53 VGND VGND VPWR VPWR sky130_fd_sc_hd__decap_3
XFILLER_32_219 VGND VGND VPWR VPWR sky130_fd_sc_hd__fill_1
X_531_ net60 _165_ VGND VGND VPWR VPWR _166_ sky130_fd_sc_hd__and2_1
X_393_ net114 net16 net48 VGND VGND VPWR VPWR _037_ sky130_fd_sc_hd__mux2_1
XTAP_TAPCELL_ROW_10_122 VGND VPWR sky130_fd_sc_hd__tapvpwrvgnd_1
XFILLER_4_79 VGND VGND VPWR VPWR sky130_fd_sc_hd__decap_4
X_600_ clknet_4_8_0_clk _050_ VGND VGND VPWR VPWR memory\[2\]\[2\] sky130_fd_sc_hd__dfxtp_1
X_462_ net161 net17 net40 VGND VGND VPWR VPWR _102_ sky130_fd_sc_hd__mux2_1
XTAP_TAPCELL_ROW_33_214 VGND VPWR sky130_fd_sc_hd__tapvpwrvgnd_1
XFILLER_38_85 VGND VGND VPWR VPWR sky130_fd_sc_hd__decap_8
XFILLER_38_41 VPWR VGND VPWR VGND sky130_ef_sc_hd__decap_12
Xfanout78 net1 VGND VGND VPWR VPWR net78 sky130_fd_sc_hd__clkbuf_2
Xfanout45 _263_ VGND VGND VPWR VPWR net45 sky130_fd_sc_hd__buf_2
XFILLER_13_55 VGND VGND VPWR VPWR sky130_fd_sc_hd__fill_1
XFILLER_1_189 VGND VGND VPWR VPWR sky130_fd_sc_hd__fill_2
X_514_ net58 _150_ VGND VGND VPWR VPWR _151_ sky130_fd_sc_hd__and2_1
Xfanout56 _135_ VGND VGND VPWR VPWR net56 sky130_fd_sc_hd__clkbuf_4
Xfanout67 net21 VGND VGND VPWR VPWR net67 sky130_fd_sc_hd__clkbuf_4
X_376_ net91 net16 net50 VGND VGND VPWR VPWR _021_ sky130_fd_sc_hd__mux2_1
X_445_ net104 net17 net42 VGND VGND VPWR VPWR _086_ sky130_fd_sc_hd__mux2_1
Xclkload9 clknet_4_12_0_clk VGND VGND VPWR VPWR clkload9/Y sky130_fd_sc_hd__bufinv_16
X_359_ net96 net16 net52 VGND VGND VPWR VPWR _005_ sky130_fd_sc_hd__mux2_1
X_428_ net17 net201 net44 VGND VGND VPWR VPWR _070_ sky130_fd_sc_hd__mux2_1
XFILLER_36_141 VPWR VGND VPWR VGND sky130_ef_sc_hd__decap_12
Xinput2 mem_access_addr[2] VGND VGND VPWR VPWR net2 sky130_fd_sc_hd__buf_1
XPHY_EDGE_ROW_2_Left_41 VGND VGND VPWR VPWR sky130_fd_sc_hd__decap_3
XFILLER_33_122 VGND VGND VPWR VPWR sky130_fd_sc_hd__decap_4
XFILLER_18_141 VGND VGND VPWR VPWR sky130_fd_sc_hd__fill_2
XFILLER_24_166 VGND VGND VPWR VPWR sky130_fd_sc_hd__decap_3
XFILLER_21_55 VGND VGND VPWR VPWR sky130_fd_sc_hd__fill_1
XFILLER_38_225 VGND VGND VPWR VPWR sky130_fd_sc_hd__decap_3
XFILLER_30_147 VGND VGND VPWR VPWR sky130_fd_sc_hd__fill_1
XTAP_TAPCELL_ROW_25_183 VGND VPWR sky130_fd_sc_hd__tapvpwrvgnd_1
XFILLER_16_3 VGND VGND VPWR VPWR sky130_fd_sc_hd__decap_3
XFILLER_15_177 VGND VGND VPWR VPWR sky130_fd_sc_hd__decap_4
XFILLER_7_57 VGND VGND VPWR VPWR sky130_fd_sc_hd__fill_2
XFILLER_29_225 VGND VGND VPWR VPWR sky130_fd_sc_hd__decap_3
XFILLER_21_169 VGND VGND VPWR VPWR sky130_fd_sc_hd__decap_4
XFILLER_21_147 VGND VGND VPWR VPWR sky130_fd_sc_hd__fill_1
XFILLER_16_22 VGND VGND VPWR VPWR sky130_fd_sc_hd__decap_6
X_676_ clknet_4_2_0_clk _126_ VGND VGND VPWR VPWR memory\[7\]\[14\] sky130_fd_sc_hd__dfxtp_1
Xhold118 memory\[7\]\[12\] VGND VGND VPWR VPWR net196 sky130_fd_sc_hd__dlygate4sd3_1
XFILLER_26_206 VGND VGND VPWR VPWR sky130_fd_sc_hd__fill_1
Xhold107 memory\[6\]\[11\] VGND VGND VPWR VPWR net185 sky130_fd_sc_hd__dlygate4sd3_1
XFILLER_7_173 VGND VGND VPWR VPWR sky130_fd_sc_hd__decap_3
X_392_ net152 net15 net48 VGND VGND VPWR VPWR _036_ sky130_fd_sc_hd__mux2_1
X_530_ memory\[4\]\[4\] memory\[5\]\[4\] net71 VGND VGND VPWR VPWR _165_ sky130_fd_sc_hd__mux2_1
X_461_ net159 net16 net41 VGND VGND VPWR VPWR _101_ sky130_fd_sc_hd__mux2_1
XTAP_TAPCELL_ROW_10_123 VGND VPWR sky130_fd_sc_hd__tapvpwrvgnd_1
XFILLER_4_121 VPWR VGND VPWR VGND sky130_ef_sc_hd__decap_12
XTAP_TAPCELL_ROW_33_215 VGND VPWR sky130_fd_sc_hd__tapvpwrvgnd_1
XPHY_EDGE_ROW_31_Left_70 VGND VGND VPWR VPWR sky130_fd_sc_hd__decap_3
X_659_ clknet_4_14_0_clk _109_ VGND VGND VPWR VPWR memory\[1\]\[13\] sky130_fd_sc_hd__dfxtp_1
XFILLER_38_53 VGND VGND VPWR VPWR sky130_fd_sc_hd__decap_3
Xfanout46 _262_ VGND VGND VPWR VPWR net46 sky130_fd_sc_hd__buf_4
Xfanout68 net21 VGND VGND VPWR VPWR net68 sky130_fd_sc_hd__clkbuf_2
Xfanout57 _135_ VGND VGND VPWR VPWR net57 sky130_fd_sc_hd__buf_2
X_375_ net206 net15 net50 VGND VGND VPWR VPWR _020_ sky130_fd_sc_hd__mux2_1
X_444_ net105 net16 net43 VGND VGND VPWR VPWR _085_ sky130_fd_sc_hd__mux2_1
X_513_ memory\[6\]\[2\] memory\[7\]\[2\] net74 VGND VGND VPWR VPWR _150_ sky130_fd_sc_hd__mux2_1
X_358_ net199 net15 net52 VGND VGND VPWR VPWR _004_ sky130_fd_sc_hd__mux2_1
X_427_ net16 net194 net45 VGND VGND VPWR VPWR _069_ sky130_fd_sc_hd__mux2_1
XFILLER_1_15 VPWR VGND VPWR VGND sky130_ef_sc_hd__decap_12
XFILLER_36_197 VGND VGND VPWR VPWR sky130_fd_sc_hd__decap_8
XFILLER_36_153 VPWR VGND VPWR VGND sky130_ef_sc_hd__decap_12
XPHY_EDGE_ROW_27_Right_27 VGND VGND VPWR VPWR sky130_fd_sc_hd__decap_3
XPHY_EDGE_ROW_18_Right_18 VGND VGND VPWR VPWR sky130_fd_sc_hd__decap_3
X_289_ net61 _197_ _201_ net54 VGND VGND VPWR VPWR _203_ sky130_fd_sc_hd__a22o_1
Xinput3 mem_access_addr[3] VGND VGND VPWR VPWR net3 sky130_fd_sc_hd__buf_1
XPHY_EDGE_ROW_36_Right_36 VGND VGND VPWR VPWR sky130_fd_sc_hd__decap_3
XFILLER_19_22 VGND VGND VPWR VPWR sky130_fd_sc_hd__decap_8
XFILLER_19_11 VGND VGND VPWR VPWR sky130_fd_sc_hd__fill_2
XFILLER_18_197 VGND VGND VPWR VPWR sky130_fd_sc_hd__fill_1
XFILLER_18_7 VGND VGND VPWR VPWR sky130_fd_sc_hd__decap_6
XTAP_TAPCELL_ROW_25_184 VGND VPWR sky130_fd_sc_hd__tapvpwrvgnd_1
XFILLER_21_126 VGND VGND VPWR VPWR sky130_fd_sc_hd__decap_3
X_675_ clknet_4_14_0_clk _125_ VGND VGND VPWR VPWR memory\[7\]\[13\] sky130_fd_sc_hd__dfxtp_1
XFILLER_16_78 VGND VGND VPWR VPWR sky130_fd_sc_hd__decap_6
XFILLER_12_104 VGND VGND VPWR VPWR sky130_fd_sc_hd__fill_1
XPHY_EDGE_ROW_0_Right_0 VGND VGND VPWR VPWR sky130_fd_sc_hd__decap_3
Xhold108 memory\[1\]\[10\] VGND VGND VPWR VPWR net186 sky130_fd_sc_hd__dlygate4sd3_1
Xhold119 memory\[1\]\[8\] VGND VGND VPWR VPWR net197 sky130_fd_sc_hd__dlygate4sd3_1
XFILLER_11_192 VGND VGND VPWR VPWR sky130_fd_sc_hd__decap_4
X_391_ net148 net14 net49 VGND VGND VPWR VPWR _035_ sky130_fd_sc_hd__mux2_1
X_460_ net143 net15 net41 VGND VGND VPWR VPWR _100_ sky130_fd_sc_hd__mux2_1
XTAP_TAPCELL_ROW_10_124 VGND VPWR sky130_fd_sc_hd__tapvpwrvgnd_1
XTAP_TAPCELL_ROW_4_100 VGND VPWR sky130_fd_sc_hd__tapvpwrvgnd_1
XTAP_TAPCELL_ROW_33_216 VGND VPWR sky130_fd_sc_hd__tapvpwrvgnd_1
X_658_ clknet_4_5_0_clk _108_ VGND VGND VPWR VPWR memory\[1\]\[12\] sky130_fd_sc_hd__dfxtp_1
XFILLER_4_15 VPWR VGND VPWR VGND sky130_ef_sc_hd__decap_12
XFILLER_4_133 VGND VGND VPWR VPWR sky130_fd_sc_hd__decap_6
X_589_ clknet_4_0_0_clk _039_ VGND VGND VPWR VPWR memory\[3\]\[7\] sky130_fd_sc_hd__dfxtp_1
Xfanout69 net70 VGND VGND VPWR VPWR net69 sky130_fd_sc_hd__clkbuf_4
XFILLER_13_57 VGND VGND VPWR VPWR sky130_fd_sc_hd__fill_1
Xfanout47 _262_ VGND VGND VPWR VPWR net47 sky130_fd_sc_hd__buf_2
XFILLER_1_103 VGND VGND VPWR VPWR sky130_fd_sc_hd__decap_8
Xfanout58 _132_ VGND VGND VPWR VPWR net58 sky130_fd_sc_hd__clkbuf_4
XFILLER_38_98 VGND VGND VPWR VPWR sky130_fd_sc_hd__decap_3
XFILLER_38_65 VGND VGND VPWR VPWR sky130_fd_sc_hd__fill_1
X_374_ net87 net14 net51 VGND VGND VPWR VPWR _019_ sky130_fd_sc_hd__mux2_1
X_443_ net95 net15 net43 VGND VGND VPWR VPWR _084_ sky130_fd_sc_hd__mux2_1
XFILLER_13_221 VGND VGND VPWR VPWR sky130_fd_sc_hd__decap_3
XFILLER_1_169 VPWR VGND VPWR VGND sky130_ef_sc_hd__decap_12
X_512_ memory\[4\]\[2\] memory\[5\]\[2\] net74 VGND VGND VPWR VPWR _149_ sky130_fd_sc_hd__mux2_1
XFILLER_1_27 VPWR VGND VPWR VGND sky130_ef_sc_hd__decap_12
XFILLER_6_3 VPWR VGND VPWR VGND sky130_ef_sc_hd__decap_12
XFILLER_36_165 VPWR VGND VPWR VGND sky130_ef_sc_hd__decap_12
XFILLER_36_121 VPWR VGND VPWR VGND sky130_ef_sc_hd__decap_12
X_426_ net15 net151 net45 VGND VGND VPWR VPWR _068_ sky130_fd_sc_hd__mux2_1
X_357_ net158 net14 net53 VGND VGND VPWR VPWR _003_ sky130_fd_sc_hd__mux2_1
X_288_ net58 _200_ net67 VGND VGND VPWR VPWR _202_ sky130_fd_sc_hd__a21o_1
Xinput4 mem_read VGND VGND VPWR VPWR net4 sky130_fd_sc_hd__clkbuf_1
XFILLER_35_44 VPWR VGND VPWR VGND sky130_ef_sc_hd__decap_12
XFILLER_27_165 VGND VGND VPWR VPWR sky130_fd_sc_hd__decap_3
XFILLER_10_25 VGND VGND VPWR VPWR sky130_fd_sc_hd__decap_3
X_409_ net102 net15 net46 VGND VGND VPWR VPWR _052_ sky130_fd_sc_hd__mux2_1
XFILLER_21_57 VGND VGND VPWR VPWR sky130_fd_sc_hd__fill_1
XTAP_TAPCELL_ROW_19_160 VGND VPWR sky130_fd_sc_hd__tapvpwrvgnd_1
XTAP_TAPCELL_ROW_25_185 VGND VPWR sky130_fd_sc_hd__tapvpwrvgnd_1
XFILLER_15_113 VGND VGND VPWR VPWR sky130_fd_sc_hd__fill_1
XFILLER_7_15 VGND VGND VPWR VPWR sky130_fd_sc_hd__decap_8
XFILLER_29_205 VGND VGND VPWR VPWR sky130_fd_sc_hd__fill_1
X_674_ clknet_4_7_0_clk _124_ VGND VGND VPWR VPWR memory\[7\]\[12\] sky130_fd_sc_hd__dfxtp_1
XFILLER_12_138 VGND VGND VPWR VPWR sky130_fd_sc_hd__fill_2
XFILLER_21_3 VGND VGND VPWR VPWR sky130_fd_sc_hd__decap_3
Xhold109 memory\[5\]\[10\] VGND VGND VPWR VPWR net187 sky130_fd_sc_hd__dlygate4sd3_1
XTAP_TAPCELL_ROW_4_101 VGND VPWR sky130_fd_sc_hd__tapvpwrvgnd_1
X_390_ net154 net13 net48 VGND VGND VPWR VPWR _034_ sky130_fd_sc_hd__mux2_1
XTAP_TAPCELL_ROW_33_217 VGND VPWR sky130_fd_sc_hd__tapvpwrvgnd_1
X_657_ clknet_4_3_0_clk _107_ VGND VGND VPWR VPWR memory\[1\]\[11\] sky130_fd_sc_hd__dfxtp_1
XTAP_TAPCELL_ROW_10_125 VGND VPWR sky130_fd_sc_hd__tapvpwrvgnd_1
XFILLER_4_27 VGND VGND VPWR VPWR sky130_fd_sc_hd__fill_1
X_588_ clknet_4_10_0_clk _038_ VGND VGND VPWR VPWR memory\[3\]\[6\] sky130_fd_sc_hd__dfxtp_1
Xfanout48 _261_ VGND VGND VPWR VPWR net48 sky130_fd_sc_hd__buf_4
Xfanout59 _132_ VGND VGND VPWR VPWR net59 sky130_fd_sc_hd__buf_2
XPHY_EDGE_ROW_18_Left_57 VGND VGND VPWR VPWR sky130_fd_sc_hd__decap_3
X_442_ net86 net14 net42 VGND VGND VPWR VPWR _083_ sky130_fd_sc_hd__mux2_1
X_511_ _143_ _146_ _147_ _148_ VGND VGND VPWR VPWR net29 sky130_fd_sc_hd__o31a_1
X_373_ net92 net13 net50 VGND VGND VPWR VPWR _018_ sky130_fd_sc_hd__mux2_1
XFILLER_0_181 VPWR VGND VPWR VGND sky130_ef_sc_hd__decap_12
Xinput5 mem_write_data[0] VGND VGND VPWR VPWR net5 sky130_fd_sc_hd__clkbuf_2
XFILLER_36_133 VGND VGND VPWR VPWR sky130_fd_sc_hd__decap_6
X_425_ net14 net180 net45 VGND VGND VPWR VPWR _067_ sky130_fd_sc_hd__mux2_1
X_287_ memory\[0\]\[8\] memory\[1\]\[8\] net76 VGND VGND VPWR VPWR _201_ sky130_fd_sc_hd__mux2_1
XFILLER_1_39 VPWR VGND VPWR VGND sky130_ef_sc_hd__decap_12
X_356_ net118 net13 net52 VGND VGND VPWR VPWR _002_ sky130_fd_sc_hd__mux2_1
XFILLER_36_177 VPWR VGND VPWR VGND sky130_ef_sc_hd__decap_12
XFILLER_27_177 VGND VGND VPWR VPWR sky130_fd_sc_hd__fill_2
XFILLER_27_155 VGND VGND VPWR VPWR sky130_fd_sc_hd__fill_1
XFILLER_19_57 VGND VGND VPWR VPWR sky130_fd_sc_hd__decap_6
XFILLER_10_37 VGND VGND VPWR VPWR sky130_fd_sc_hd__decap_4
X_408_ net147 net14 net47 VGND VGND VPWR VPWR _051_ sky130_fd_sc_hd__mux2_1
XFILLER_33_169 VGND VGND VPWR VPWR sky130_fd_sc_hd__fill_2
XTAP_TAPCELL_ROW_28_194 VGND VPWR sky130_fd_sc_hd__tapvpwrvgnd_1
XFILLER_18_100 VGND VGND VPWR VPWR sky130_fd_sc_hd__decap_8
XTAP_TAPCELL_ROW_19_161 VGND VPWR sky130_fd_sc_hd__tapvpwrvgnd_1
XFILLER_2_82 VGND VGND VPWR VPWR sky130_fd_sc_hd__fill_2
X_339_ memory\[0\]\[14\] memory\[1\]\[14\] net70 VGND VGND VPWR VPWR _247_ sky130_fd_sc_hd__mux2_1
XFILLER_15_147 VGND VGND VPWR VPWR sky130_fd_sc_hd__decap_4
XPHY_EDGE_ROW_6_Left_45 VGND VGND VPWR VPWR sky130_fd_sc_hd__decap_3
XFILLER_21_117 VGND VGND VPWR VPWR sky130_fd_sc_hd__fill_1
Xclkbuf_4_9_0_clk clknet_0_clk VGND VGND VPWR VPWR clknet_4_9_0_clk sky130_fd_sc_hd__clkbuf_8
XFILLER_20_172 VGND VGND VPWR VPWR sky130_fd_sc_hd__decap_3
XFILLER_20_150 VGND VGND VPWR VPWR sky130_fd_sc_hd__decap_4
XTAP_TAPCELL_ROW_7_110 VGND VPWR sky130_fd_sc_hd__tapvpwrvgnd_1
XTAP_TAPCELL_ROW_13_134 VGND VPWR sky130_fd_sc_hd__tapvpwrvgnd_1
X_673_ clknet_4_2_0_clk _123_ VGND VGND VPWR VPWR memory\[7\]\[11\] sky130_fd_sc_hd__dfxtp_1
XFILLER_7_165 VGND VGND VPWR VPWR sky130_fd_sc_hd__decap_3
XTAP_TAPCELL_ROW_36_226 VGND VPWR sky130_fd_sc_hd__tapvpwrvgnd_1
XFILLER_8_81 VGND VGND VPWR VPWR sky130_fd_sc_hd__decap_3
X_656_ clknet_4_14_0_clk _106_ VGND VGND VPWR VPWR memory\[1\]\[10\] sky130_fd_sc_hd__dfxtp_1
X_587_ clknet_4_4_0_clk _037_ VGND VGND VPWR VPWR memory\[3\]\[5\] sky130_fd_sc_hd__dfxtp_1
Xfanout38 _266_ VGND VGND VPWR VPWR net38 sky130_fd_sc_hd__buf_4
Xfanout49 _261_ VGND VGND VPWR VPWR net49 sky130_fd_sc_hd__buf_2
XPHY_EDGE_ROW_35_Left_74 VGND VGND VPWR VPWR sky130_fd_sc_hd__decap_3
X_510_ net63 net12 net65 VGND VGND VPWR VPWR _148_ sky130_fd_sc_hd__o21a_1
X_372_ net107 net12 net50 VGND VGND VPWR VPWR _017_ sky130_fd_sc_hd__mux2_1
X_441_ net115 net13 net42 VGND VGND VPWR VPWR _082_ sky130_fd_sc_hd__mux2_1
X_639_ clknet_4_3_0_clk _089_ VGND VGND VPWR VPWR memory\[6\]\[9\] sky130_fd_sc_hd__dfxtp_1
XFILLER_0_193 VGND VGND VPWR VPWR sky130_fd_sc_hd__decap_3
XFILLER_10_226 VGND VGND VPWR VPWR sky130_fd_sc_hd__fill_2
XFILLER_5_71 VGND VGND VPWR VPWR sky130_fd_sc_hd__decap_6
X_286_ memory\[6\]\[8\] memory\[7\]\[8\] net74 VGND VGND VPWR VPWR _200_ sky130_fd_sc_hd__mux2_1
X_355_ net110 net12 net52 VGND VGND VPWR VPWR _001_ sky130_fd_sc_hd__mux2_1
X_424_ net13 net203 net44 VGND VGND VPWR VPWR _066_ sky130_fd_sc_hd__mux2_1
XFILLER_36_189 VGND VGND VPWR VPWR sky130_fd_sc_hd__decap_6
Xinput6 mem_write_data[10] VGND VGND VPWR VPWR net6 sky130_fd_sc_hd__clkbuf_2
XFILLER_19_36 VGND VGND VPWR VPWR sky130_fd_sc_hd__decap_8
XFILLER_35_57 VPWR VGND VPWR VGND sky130_ef_sc_hd__decap_12
XPHY_EDGE_ROW_23_Right_23 VGND VGND VPWR VPWR sky130_fd_sc_hd__decap_3
XPHY_EDGE_ROW_14_Right_14 VGND VGND VPWR VPWR sky130_fd_sc_hd__decap_3
XFILLER_33_126 VGND VGND VPWR VPWR sky130_fd_sc_hd__fill_1
XPHY_EDGE_ROW_32_Right_32 VGND VGND VPWR VPWR sky130_fd_sc_hd__decap_3
XTAP_TAPCELL_ROW_28_195 VGND VPWR sky130_fd_sc_hd__tapvpwrvgnd_1
XPHY_EDGE_ROW_22_Left_61 VGND VGND VPWR VPWR sky130_fd_sc_hd__decap_3
X_269_ memory\[6\]\[6\] memory\[7\]\[6\] net74 VGND VGND VPWR VPWR _185_ sky130_fd_sc_hd__mux2_1
X_338_ memory\[2\]\[14\] memory\[3\]\[14\] net69 VGND VGND VPWR VPWR _246_ sky130_fd_sc_hd__mux2_1
X_407_ net138 net13 net46 VGND VGND VPWR VPWR _050_ sky130_fd_sc_hd__mux2_1
XFILLER_32_170 VGND VGND VPWR VPWR sky130_fd_sc_hd__decap_6
XFILLER_30_118 VGND VGND VPWR VPWR sky130_fd_sc_hd__decap_6
Xinput20 mem_write_data[9] VGND VGND VPWR VPWR net20 sky130_fd_sc_hd__clkbuf_2
XFILLER_16_48 VGND VGND VPWR VPWR sky130_fd_sc_hd__fill_1
X_672_ clknet_4_13_0_clk _122_ VGND VGND VPWR VPWR memory\[7\]\[10\] sky130_fd_sc_hd__dfxtp_1
XTAP_TAPCELL_ROW_13_135 VGND VPWR sky130_fd_sc_hd__tapvpwrvgnd_1
XFILLER_11_173 VGND VGND VPWR VPWR sky130_fd_sc_hd__decap_3
XTAP_TAPCELL_ROW_7_111 VGND VPWR sky130_fd_sc_hd__tapvpwrvgnd_1
XTAP_TAPCELL_ROW_36_227 VGND VPWR sky130_fd_sc_hd__tapvpwrvgnd_1
XPHY_EDGE_ROW_4_Right_4 VGND VGND VPWR VPWR sky130_fd_sc_hd__decap_3
XFILLER_8_60 VGND VGND VPWR VPWR sky130_fd_sc_hd__fill_1
Xclkbuf_4_8_0_clk clknet_0_clk VGND VGND VPWR VPWR clknet_4_8_0_clk sky130_fd_sc_hd__clkbuf_8
XFILLER_4_147 VPWR VGND VPWR VGND sky130_ef_sc_hd__decap_12
X_586_ clknet_4_5_0_clk _036_ VGND VGND VPWR VPWR memory\[3\]\[4\] sky130_fd_sc_hd__dfxtp_1
X_655_ clknet_4_3_0_clk _105_ VGND VGND VPWR VPWR memory\[1\]\[9\] sky130_fd_sc_hd__dfxtp_1
XFILLER_38_57 VGND VGND VPWR VPWR sky130_fd_sc_hd__decap_8
X_371_ net134 net5 net50 VGND VGND VPWR VPWR _016_ sky130_fd_sc_hd__mux2_1
Xfanout39 _266_ VGND VGND VPWR VPWR net39 sky130_fd_sc_hd__buf_2
X_440_ net116 net12 net42 VGND VGND VPWR VPWR _081_ sky130_fd_sc_hd__mux2_1
X_569_ clknet_4_15_0_clk _019_ VGND VGND VPWR VPWR memory\[4\]\[3\] sky130_fd_sc_hd__dfxtp_1
X_638_ clknet_4_9_0_clk _088_ VGND VGND VPWR VPWR memory\[6\]\[8\] sky130_fd_sc_hd__dfxtp_1
XFILLER_24_26 VGND VGND VPWR VPWR sky130_fd_sc_hd__fill_2
XFILLER_6_209 VGND VGND VPWR VPWR sky130_fd_sc_hd__fill_2
X_354_ net111 net5 net52 VGND VGND VPWR VPWR _000_ sky130_fd_sc_hd__mux2_1
X_285_ net56 _198_ VGND VGND VPWR VPWR _199_ sky130_fd_sc_hd__and2_1
X_423_ net12 net188 net44 VGND VGND VPWR VPWR _065_ sky130_fd_sc_hd__mux2_1
Xinput7 mem_write_data[11] VGND VGND VPWR VPWR net7 sky130_fd_sc_hd__clkbuf_2
XFILLER_35_69 VPWR VGND VPWR VGND sky130_ef_sc_hd__decap_12
XFILLER_27_113 VGND VGND VPWR VPWR sky130_fd_sc_hd__fill_1
XFILLER_4_3 VPWR VGND VPWR VGND sky130_ef_sc_hd__decap_12
XFILLER_37_3 VPWR VGND VPWR VGND sky130_ef_sc_hd__decap_12
XTAP_TAPCELL_ROW_28_196 VGND VPWR sky130_fd_sc_hd__tapvpwrvgnd_1
X_406_ net145 net12 net46 VGND VGND VPWR VPWR _049_ sky130_fd_sc_hd__mux2_1
X_337_ net58 _244_ VGND VGND VPWR VPWR _245_ sky130_fd_sc_hd__and2_1
X_268_ memory\[0\]\[6\] memory\[1\]\[6\] net74 VGND VGND VPWR VPWR _184_ sky130_fd_sc_hd__mux2_1
XFILLER_24_138 VGND VGND VPWR VPWR sky130_fd_sc_hd__fill_2
XFILLER_30_108 VGND VGND VPWR VPWR sky130_fd_sc_hd__fill_2
XFILLER_32_15 VGND VGND VPWR VPWR sky130_fd_sc_hd__decap_6
Xinput10 mem_write_data[14] VGND VGND VPWR VPWR net10 sky130_fd_sc_hd__clkbuf_2
Xinput21 mem_write_en VGND VGND VPWR VPWR net21 sky130_fd_sc_hd__buf_1
X_671_ clknet_4_3_0_clk _121_ VGND VGND VPWR VPWR memory\[7\]\[9\] sky130_fd_sc_hd__dfxtp_1
XTAP_TAPCELL_ROW_13_136 VGND VPWR sky130_fd_sc_hd__tapvpwrvgnd_1
XFILLER_11_196 VGND VGND VPWR VPWR sky130_fd_sc_hd__fill_1
XTAP_TAPCELL_ROW_7_112 VGND VPWR sky130_fd_sc_hd__tapvpwrvgnd_1
XTAP_TAPCELL_ROW_36_228 VGND VPWR sky130_fd_sc_hd__tapvpwrvgnd_1
XFILLER_4_159 VGND VGND VPWR VPWR sky130_fd_sc_hd__decap_4
X_585_ clknet_4_15_0_clk _035_ VGND VGND VPWR VPWR memory\[3\]\[3\] sky130_fd_sc_hd__dfxtp_1
XFILLER_31_225 VGND VGND VPWR VPWR sky130_fd_sc_hd__decap_3
X_654_ clknet_4_6_0_clk _104_ VGND VGND VPWR VPWR memory\[1\]\[8\] sky130_fd_sc_hd__dfxtp_1
XFILLER_13_225 VGND VGND VPWR VPWR sky130_fd_sc_hd__decap_3
X_370_ net69 net66 net60 VGND VGND VPWR VPWR _260_ sky130_fd_sc_hd__and3b_1
X_637_ clknet_4_3_0_clk _087_ VGND VGND VPWR VPWR memory\[6\]\[7\] sky130_fd_sc_hd__dfxtp_1
X_499_ memory\[0\]\[0\] memory\[1\]\[0\] net72 VGND VGND VPWR VPWR _138_ sky130_fd_sc_hd__mux2_1
Xclkbuf_4_7_0_clk clknet_0_clk VGND VGND VPWR VPWR clknet_4_7_0_clk sky130_fd_sc_hd__clkbuf_8
XFILLER_5_51 VGND VGND VPWR VPWR sky130_fd_sc_hd__decap_4
X_568_ clknet_4_8_0_clk _018_ VGND VGND VPWR VPWR memory\[4\]\[2\] sky130_fd_sc_hd__dfxtp_1
X_422_ net5 net165 net44 VGND VGND VPWR VPWR _064_ sky130_fd_sc_hd__mux2_1
X_284_ memory\[2\]\[8\] memory\[3\]\[8\] net74 VGND VGND VPWR VPWR _198_ sky130_fd_sc_hd__mux2_1
X_353_ net69 net66 net60 VGND VGND VPWR VPWR _259_ sky130_fd_sc_hd__and3_1
Xinput8 mem_write_data[12] VGND VGND VPWR VPWR net8 sky130_fd_sc_hd__clkbuf_2
XFILLER_14_93 VGND VGND VPWR VPWR sky130_fd_sc_hd__decap_4
XFILLER_2_213 VPWR VGND VPWR VGND sky130_ef_sc_hd__decap_12
X_405_ net84 net5 net46 VGND VGND VPWR VPWR _048_ sky130_fd_sc_hd__mux2_1
XTAP_TAPCELL_ROW_28_197 VGND VPWR sky130_fd_sc_hd__tapvpwrvgnd_1
X_336_ memory\[6\]\[14\] memory\[7\]\[14\] net70 VGND VGND VPWR VPWR _244_ sky130_fd_sc_hd__mux2_1
X_267_ memory\[4\]\[6\] memory\[5\]\[6\] net74 VGND VGND VPWR VPWR _183_ sky130_fd_sc_hd__mux2_1
XFILLER_2_85 VGND VGND VPWR VPWR sky130_fd_sc_hd__fill_2
XFILLER_2_41 VPWR VGND VPWR VGND sky130_ef_sc_hd__decap_12
XFILLER_38_209 VPWR VGND VPWR VGND sky130_ef_sc_hd__decap_12
XFILLER_11_61 VGND VGND VPWR VPWR sky130_fd_sc_hd__fill_1
Xinput11 mem_write_data[15] VGND VGND VPWR VPWR net11 sky130_fd_sc_hd__clkbuf_2
X_319_ net55 _228_ VGND VGND VPWR VPWR _229_ sky130_fd_sc_hd__and2_1
XFILLER_21_109 VGND VGND VPWR VPWR sky130_fd_sc_hd__decap_3
XFILLER_20_197 VGND VGND VPWR VPWR sky130_fd_sc_hd__decap_4
X_670_ clknet_4_9_0_clk _120_ VGND VGND VPWR VPWR memory\[7\]\[8\] sky130_fd_sc_hd__dfxtp_1
XTAP_TAPCELL_ROW_7_113 VGND VPWR sky130_fd_sc_hd__tapvpwrvgnd_1
XTAP_TAPCELL_ROW_36_229 VGND VPWR sky130_fd_sc_hd__tapvpwrvgnd_1
XTAP_TAPCELL_ROW_13_137 VGND VPWR sky130_fd_sc_hd__tapvpwrvgnd_1
XFILLER_25_223 VGND VGND VPWR VPWR sky130_fd_sc_hd__fill_1
X_653_ clknet_4_1_0_clk _103_ VGND VGND VPWR VPWR memory\[1\]\[7\] sky130_fd_sc_hd__dfxtp_1
X_584_ clknet_4_8_0_clk _034_ VGND VGND VPWR VPWR memory\[3\]\[2\] sky130_fd_sc_hd__dfxtp_1
XTAP_TAPCELL_ROW_32_210 VGND VPWR sky130_fd_sc_hd__tapvpwrvgnd_1
XFILLER_12_3 VGND VGND VPWR VPWR sky130_fd_sc_hd__decap_3
XFILLER_38_15 VPWR VGND VPWR VGND sky130_ef_sc_hd__decap_12
XFILLER_0_141 VGND VGND VPWR VPWR sky130_fd_sc_hd__fill_2
X_567_ clknet_4_9_0_clk _017_ VGND VGND VPWR VPWR memory\[4\]\[1\] sky130_fd_sc_hd__dfxtp_1
X_636_ clknet_4_10_0_clk _086_ VGND VGND VPWR VPWR memory\[6\]\[6\] sky130_fd_sc_hd__dfxtp_1
X_498_ net2 net3 VGND VGND VPWR VPWR _137_ sky130_fd_sc_hd__nor2_1
X_421_ net73 net62 net54 VGND VGND VPWR VPWR _263_ sky130_fd_sc_hd__or3b_1
X_352_ _252_ _256_ _257_ _258_ VGND VGND VPWR VPWR net28 sky130_fd_sc_hd__o31a_1
XFILLER_30_93 VGND VGND VPWR VPWR sky130_fd_sc_hd__fill_2
X_619_ clknet_4_6_0_clk _069_ VGND VGND VPWR VPWR memory\[0\]\[5\] sky130_fd_sc_hd__dfxtp_1
Xinput9 mem_write_data[13] VGND VGND VPWR VPWR net9 sky130_fd_sc_hd__clkbuf_2
X_283_ memory\[4\]\[8\] memory\[5\]\[8\] net76 VGND VGND VPWR VPWR _197_ sky130_fd_sc_hd__mux2_1
XTAP_TAPCELL_ROW_1_86 VGND VPWR sky130_fd_sc_hd__tapvpwrvgnd_1
XFILLER_35_181 VGND VGND VPWR VPWR sky130_fd_sc_hd__decap_8
XFILLER_35_27 VGND VGND VPWR VPWR sky130_fd_sc_hd__decap_3
Xclkbuf_4_6_0_clk clknet_0_clk VGND VGND VPWR VPWR clknet_4_6_0_clk sky130_fd_sc_hd__clkbuf_8
X_404_ net72 net68 net57 VGND VGND VPWR VPWR _262_ sky130_fd_sc_hd__and3b_1
XFILLER_18_137 VGND VGND VPWR VPWR sky130_fd_sc_hd__decap_3
XFILLER_2_225 VGND VGND VPWR VPWR sky130_fd_sc_hd__decap_3
X_335_ memory\[4\]\[14\] memory\[5\]\[14\] net70 VGND VGND VPWR VPWR _243_ sky130_fd_sc_hd__mux2_1
XFILLER_32_195 VGND VGND VPWR VPWR sky130_fd_sc_hd__fill_1
XFILLER_32_151 VGND VGND VPWR VPWR sky130_fd_sc_hd__fill_1
XPHY_EDGE_ROW_10_Right_10 VGND VGND VPWR VPWR sky130_fd_sc_hd__decap_3
XFILLER_2_53 VGND VGND VPWR VPWR sky130_fd_sc_hd__decap_4
X_318_ memory\[0\]\[12\] memory\[1\]\[12\] net71 VGND VGND VPWR VPWR _228_ sky130_fd_sc_hd__mux2_1
XPHY_EDGE_ROW_26_Left_65 VGND VGND VPWR VPWR sky130_fd_sc_hd__decap_3
XTAP_TAPCELL_ROW_16_146 VGND VPWR sky130_fd_sc_hd__tapvpwrvgnd_1
Xinput12 mem_write_data[1] VGND VGND VPWR VPWR net12 sky130_fd_sc_hd__clkbuf_2
XPHY_EDGE_ROW_10_Left_49 VGND VGND VPWR VPWR sky130_fd_sc_hd__decap_3
XFILLER_20_154 VGND VGND VPWR VPWR sky130_fd_sc_hd__fill_1
XFILLER_16_29 VGND VGND VPWR VPWR sky130_fd_sc_hd__decap_3
XFILLER_22_83 VGND VGND VPWR VPWR sky130_fd_sc_hd__fill_1
XFILLER_14_7 VGND VGND VPWR VPWR sky130_fd_sc_hd__decap_6
XFILLER_11_121 VGND VGND VPWR VPWR sky130_fd_sc_hd__decap_6
XFILLER_8_85 VGND VGND VPWR VPWR sky130_fd_sc_hd__decap_3
XFILLER_17_83 VGND VGND VPWR VPWR sky130_fd_sc_hd__decap_4
X_583_ clknet_4_11_0_clk _033_ VGND VGND VPWR VPWR memory\[3\]\[1\] sky130_fd_sc_hd__dfxtp_1
XFILLER_4_139 VGND VGND VPWR VPWR sky130_fd_sc_hd__fill_1
X_652_ clknet_4_10_0_clk _102_ VGND VGND VPWR VPWR memory\[1\]\[6\] sky130_fd_sc_hd__dfxtp_1
XTAP_TAPCELL_ROW_32_211 VGND VPWR sky130_fd_sc_hd__tapvpwrvgnd_1
Xhold1 memory\[2\]\[7\] VGND VGND VPWR VPWR net79 sky130_fd_sc_hd__dlygate4sd3_1
XFILLER_3_161 VGND VGND VPWR VPWR sky130_fd_sc_hd__decap_6
XPHY_EDGE_ROW_8_Right_8 VGND VGND VPWR VPWR sky130_fd_sc_hd__decap_3
XFILLER_38_27 VGND VGND VPWR VPWR sky130_fd_sc_hd__fill_1
XPHY_EDGE_ROW_13_Left_52 VGND VGND VPWR VPWR sky130_fd_sc_hd__decap_3
X_497_ memory\[2\]\[0\] memory\[3\]\[0\] net72 VGND VGND VPWR VPWR _136_ sky130_fd_sc_hd__mux2_1
X_566_ clknet_4_6_0_clk _016_ VGND VGND VPWR VPWR memory\[4\]\[0\] sky130_fd_sc_hd__dfxtp_1
X_635_ clknet_4_6_0_clk _085_ VGND VGND VPWR VPWR memory\[6\]\[5\] sky130_fd_sc_hd__dfxtp_1
XFILLER_0_197 VPWR VGND VPWR VGND sky130_ef_sc_hd__decap_12
XFILLER_24_18 VGND VGND VPWR VPWR sky130_fd_sc_hd__decap_8
XFILLER_10_208 VGND VGND VPWR VPWR sky130_fd_sc_hd__fill_1
X_420_ net88 net11 net47 VGND VGND VPWR VPWR _063_ sky130_fd_sc_hd__mux2_1
X_351_ net63 net11 net65 VGND VGND VPWR VPWR _258_ sky130_fd_sc_hd__o21a_1
X_282_ _190_ _194_ _195_ _196_ VGND VGND VPWR VPWR net35 sky130_fd_sc_hd__o31a_1
XTAP_TAPCELL_ROW_1_87 VGND VPWR sky130_fd_sc_hd__tapvpwrvgnd_1
XFILLER_5_223 VGND VGND VPWR VPWR sky130_fd_sc_hd__fill_1
X_618_ clknet_4_5_0_clk _068_ VGND VGND VPWR VPWR memory\[0\]\[4\] sky130_fd_sc_hd__dfxtp_1
XFILLER_27_149 VGND VGND VPWR VPWR sky130_fd_sc_hd__decap_6
X_549_ net57 _181_ VGND VGND VPWR VPWR _182_ sky130_fd_sc_hd__and2_1
X_403_ net169 net11 net49 VGND VGND VPWR VPWR _047_ sky130_fd_sc_hd__mux2_1
XFILLER_26_193 VGND VGND VPWR VPWR sky130_fd_sc_hd__decap_3
X_334_ _239_ _240_ _241_ _242_ VGND VGND VPWR VPWR net26 sky130_fd_sc_hd__o31a_1
XFILLER_32_130 VGND VGND VPWR VPWR sky130_fd_sc_hd__fill_1
XFILLER_17_193 VGND VGND VPWR VPWR sky130_fd_sc_hd__fill_2
XFILLER_15_108 VGND VGND VPWR VPWR sky130_fd_sc_hd__decap_4
X_317_ memory\[4\]\[12\] memory\[5\]\[12\] net71 VGND VGND VPWR VPWR _227_ sky130_fd_sc_hd__mux2_1
XTAP_TAPCELL_ROW_24_180 VGND VPWR sky130_fd_sc_hd__tapvpwrvgnd_1
XTAP_TAPCELL_ROW_16_147 VGND VPWR sky130_fd_sc_hd__tapvpwrvgnd_1
XFILLER_2_3 VPWR VGND VPWR VGND sky130_ef_sc_hd__decap_12
Xinput13 mem_write_data[2] VGND VGND VPWR VPWR net13 sky130_fd_sc_hd__clkbuf_2
XPHY_EDGE_ROW_1_Left_40 VGND VGND VPWR VPWR sky130_fd_sc_hd__decap_3
XFILLER_32_29 VGND VGND VPWR VPWR sky130_fd_sc_hd__fill_2
XFILLER_28_211 VGND VGND VPWR VPWR sky130_fd_sc_hd__fill_1
Xclkbuf_4_5_0_clk clknet_0_clk VGND VGND VPWR VPWR clknet_4_5_0_clk sky130_fd_sc_hd__clkbuf_8
XFILLER_11_111 VGND VGND VPWR VPWR sky130_fd_sc_hd__fill_1
XFILLER_7_148 VGND VGND VPWR VPWR sky130_fd_sc_hd__fill_1
XFILLER_34_225 VGND VGND VPWR VPWR sky130_fd_sc_hd__decap_3
X_582_ clknet_4_7_0_clk _032_ VGND VGND VPWR VPWR memory\[3\]\[0\] sky130_fd_sc_hd__dfxtp_1
XFILLER_25_225 VGND VGND VPWR VPWR sky130_fd_sc_hd__decap_3
X_651_ clknet_4_6_0_clk _101_ VGND VGND VPWR VPWR memory\[1\]\[5\] sky130_fd_sc_hd__dfxtp_1
XTAP_TAPCELL_ROW_32_212 VGND VPWR sky130_fd_sc_hd__tapvpwrvgnd_1
Xhold2 memory\[2\]\[9\] VGND VGND VPWR VPWR net80 sky130_fd_sc_hd__dlygate4sd3_1
XTAP_TAPCELL_ROW_4_98 VGND VPWR sky130_fd_sc_hd__tapvpwrvgnd_1
X_634_ clknet_4_7_0_clk _084_ VGND VGND VPWR VPWR memory\[6\]\[4\] sky130_fd_sc_hd__dfxtp_1
X_565_ clknet_4_12_0_clk _015_ VGND VGND VPWR VPWR memory\[5\]\[15\] sky130_fd_sc_hd__dfxtp_1
X_496_ net3 net2 VGND VGND VPWR VPWR _135_ sky130_fd_sc_hd__and2b_1
X_350_ net55 _253_ _255_ net61 VGND VGND VPWR VPWR _257_ sky130_fd_sc_hd__a22o_1
XFILLER_14_63 VGND VGND VPWR VPWR sky130_fd_sc_hd__decap_4
X_281_ net62 net18 net64 VGND VGND VPWR VPWR _196_ sky130_fd_sc_hd__o21a_1
XTAP_TAPCELL_ROW_1_88 VGND VPWR sky130_fd_sc_hd__tapvpwrvgnd_1
XFILLER_36_139 VGND VGND VPWR VPWR sky130_fd_sc_hd__fill_1
X_617_ clknet_4_15_0_clk _067_ VGND VGND VPWR VPWR memory\[0\]\[3\] sky130_fd_sc_hd__dfxtp_1
X_479_ net177 net17 net38 VGND VGND VPWR VPWR _118_ sky130_fd_sc_hd__mux2_1
X_548_ memory\[2\]\[6\] memory\[3\]\[6\] net75 VGND VGND VPWR VPWR _181_ sky130_fd_sc_hd__mux2_1
XFILLER_25_73 VGND VGND VPWR VPWR sky130_fd_sc_hd__fill_1
X_333_ net63 net9 net65 VGND VGND VPWR VPWR _242_ sky130_fd_sc_hd__o21a_1
X_402_ net150 net10 net48 VGND VGND VPWR VPWR _046_ sky130_fd_sc_hd__mux2_1
XFILLER_23_164 VGND VGND VPWR VPWR sky130_fd_sc_hd__decap_4
XFILLER_36_83 VGND VGND VPWR VPWR sky130_fd_sc_hd__fill_1
Xinput14 mem_write_data[3] VGND VGND VPWR VPWR net14 sky130_fd_sc_hd__clkbuf_2
XTAP_TAPCELL_ROW_24_181 VGND VPWR sky130_fd_sc_hd__tapvpwrvgnd_1
XTAP_TAPCELL_ROW_16_148 VGND VPWR sky130_fd_sc_hd__tapvpwrvgnd_1
XFILLER_14_197 VGND VGND VPWR VPWR sky130_fd_sc_hd__fill_1
XFILLER_14_186 VGND VGND VPWR VPWR sky130_fd_sc_hd__fill_2
XFILLER_11_20 VGND VGND VPWR VPWR sky130_fd_sc_hd__decap_3
X_316_ _221_ _224_ _225_ _226_ VGND VGND VPWR VPWR net24 sky130_fd_sc_hd__o31a_1
XFILLER_20_123 VGND VGND VPWR VPWR sky130_fd_sc_hd__fill_1
XFILLER_20_101 VGND VGND VPWR VPWR sky130_fd_sc_hd__decap_6
XTAP_TAPCELL_ROW_38_240 VGND VPWR sky130_fd_sc_hd__tapvpwrvgnd_1
XFILLER_11_167 VGND VGND VPWR VPWR sky130_fd_sc_hd__fill_1
X_650_ clknet_4_5_0_clk _100_ VGND VGND VPWR VPWR memory\[1\]\[4\] sky130_fd_sc_hd__dfxtp_1
XFILLER_27_19 VGND VGND VPWR VPWR sky130_fd_sc_hd__decap_3
XFILLER_25_204 VGND VGND VPWR VPWR sky130_fd_sc_hd__decap_3
XFILLER_33_73 VGND VGND VPWR VPWR sky130_fd_sc_hd__fill_2
X_581_ clknet_4_12_0_clk _031_ VGND VGND VPWR VPWR memory\[4\]\[15\] sky130_fd_sc_hd__dfxtp_1
XFILLER_16_226 VGND VGND VPWR VPWR sky130_fd_sc_hd__fill_2
Xhold3 memory\[6\]\[8\] VGND VGND VPWR VPWR net81 sky130_fd_sc_hd__dlygate4sd3_1
XFILLER_3_141 VGND VGND VPWR VPWR sky130_fd_sc_hd__decap_3
XFILLER_3_185 VPWR VGND VPWR VGND sky130_ef_sc_hd__decap_12
XTAP_TAPCELL_ROW_4_99 VGND VPWR sky130_fd_sc_hd__tapvpwrvgnd_1
XFILLER_38_29 VPWR VGND VPWR VGND sky130_ef_sc_hd__decap_12
XTAP_TAPCELL_ROW_32_213 VGND VPWR sky130_fd_sc_hd__tapvpwrvgnd_1
Xclkbuf_4_4_0_clk clknet_0_clk VGND VGND VPWR VPWR clknet_4_4_0_clk sky130_fd_sc_hd__clkbuf_8
X_633_ clknet_4_15_0_clk _083_ VGND VGND VPWR VPWR memory\[6\]\[3\] sky130_fd_sc_hd__dfxtp_1
X_495_ net59 _133_ VGND VGND VPWR VPWR _134_ sky130_fd_sc_hd__and2_1
XFILLER_0_133 VGND VGND VPWR VPWR sky130_fd_sc_hd__decap_3
XFILLER_0_111 VGND VGND VPWR VPWR sky130_fd_sc_hd__fill_1
X_564_ clknet_4_0_0_clk _014_ VGND VGND VPWR VPWR memory\[5\]\[14\] sky130_fd_sc_hd__dfxtp_1
XFILLER_5_55 VGND VGND VPWR VPWR sky130_fd_sc_hd__fill_1
XFILLER_5_77 VGND VGND VPWR VPWR sky130_fd_sc_hd__fill_1
XFILLER_10_3 VGND VGND VPWR VPWR sky130_fd_sc_hd__decap_4
XFILLER_38_181 VPWR VGND VPWR VGND sky130_ef_sc_hd__decap_12
XFILLER_14_53 VGND VGND VPWR VPWR sky130_fd_sc_hd__decap_4
XFILLER_5_203 VGND VGND VPWR VPWR sky130_fd_sc_hd__fill_2
XFILLER_5_225 VGND VGND VPWR VPWR sky130_fd_sc_hd__decap_3
X_280_ net54 _191_ _193_ net56 VGND VGND VPWR VPWR _195_ sky130_fd_sc_hd__a22o_1
XFILLER_30_85 VGND VGND VPWR VPWR sky130_fd_sc_hd__decap_8
X_478_ net109 net16 net39 VGND VGND VPWR VPWR _117_ sky130_fd_sc_hd__mux2_1
X_547_ _175_ _178_ _179_ _180_ VGND VGND VPWR VPWR net33 sky130_fd_sc_hd__o31a_1
X_616_ clknet_4_9_0_clk _066_ VGND VGND VPWR VPWR memory\[0\]\[2\] sky130_fd_sc_hd__dfxtp_1
XTAP_TAPCELL_ROW_1_89 VGND VPWR sky130_fd_sc_hd__tapvpwrvgnd_1
X_332_ net59 _235_ _236_ net55 VGND VGND VPWR VPWR _241_ sky130_fd_sc_hd__a22o_1
X_401_ net163 net9 net49 VGND VGND VPWR VPWR _045_ sky130_fd_sc_hd__mux2_1
XFILLER_32_176 VGND VGND VPWR VPWR sky130_fd_sc_hd__fill_1
XTAP_TAPCELL_ROW_27_190 VGND VPWR sky130_fd_sc_hd__tapvpwrvgnd_1
XFILLER_23_154 VGND VGND VPWR VPWR sky130_fd_sc_hd__fill_1
XTAP_TAPCELL_ROW_16_149 VGND VPWR sky130_fd_sc_hd__tapvpwrvgnd_1
XFILLER_14_110 VGND VGND VPWR VPWR sky130_fd_sc_hd__decap_4
Xinput15 mem_write_data[4] VGND VGND VPWR VPWR net15 sky130_fd_sc_hd__clkbuf_2
XFILLER_37_213 VGND VGND VPWR VPWR sky130_fd_sc_hd__decap_3
X_315_ net62 net7 net64 VGND VGND VPWR VPWR _226_ sky130_fd_sc_hd__o21a_1
XTAP_TAPCELL_ROW_38_241 VGND VPWR sky130_fd_sc_hd__tapvpwrvgnd_1
XTAP_TAPCELL_ROW_12_130 VGND VPWR sky130_fd_sc_hd__tapvpwrvgnd_1
XFILLER_6_183 VGND VGND VPWR VPWR sky130_fd_sc_hd__fill_1
XTAP_TAPCELL_ROW_35_222 VGND VPWR sky130_fd_sc_hd__tapvpwrvgnd_1
XFILLER_31_219 VGND VGND VPWR VPWR sky130_fd_sc_hd__fill_1
X_580_ clknet_4_0_0_clk _030_ VGND VGND VPWR VPWR memory\[4\]\[14\] sky130_fd_sc_hd__dfxtp_1
Xhold4 memory\[4\]\[11\] VGND VGND VPWR VPWR net82 sky130_fd_sc_hd__dlygate4sd3_1
XFILLER_28_96 VGND VGND VPWR VPWR sky130_fd_sc_hd__fill_1
XFILLER_28_85 VGND VGND VPWR VPWR sky130_fd_sc_hd__fill_2
XPHY_EDGE_ROW_26_Right_26 VGND VGND VPWR VPWR sky130_fd_sc_hd__decap_3
X_563_ clknet_4_11_0_clk _013_ VGND VGND VPWR VPWR memory\[5\]\[13\] sky130_fd_sc_hd__dfxtp_1
XPHY_EDGE_ROW_17_Right_17 VGND VGND VPWR VPWR sky130_fd_sc_hd__decap_3
XFILLER_0_167 VGND VGND VPWR VPWR sky130_fd_sc_hd__fill_1
X_632_ clknet_4_8_0_clk _082_ VGND VGND VPWR VPWR memory\[6\]\[2\] sky130_fd_sc_hd__dfxtp_1
XPHY_EDGE_ROW_35_Right_35 VGND VGND VPWR VPWR sky130_fd_sc_hd__decap_3
X_494_ memory\[6\]\[0\] memory\[7\]\[0\] net72 VGND VGND VPWR VPWR _133_ sky130_fd_sc_hd__mux2_1
XFILLER_8_223 VGND VGND VPWR VPWR sky130_fd_sc_hd__fill_1
XFILLER_38_193 VGND VGND VPWR VPWR sky130_fd_sc_hd__decap_3
XPHY_EDGE_ROW_17_Left_56 VGND VGND VPWR VPWR sky130_fd_sc_hd__decap_3
X_477_ net141 net15 net39 VGND VGND VPWR VPWR _116_ sky130_fd_sc_hd__mux2_1
X_546_ net62 net16 net64 VGND VGND VPWR VPWR _180_ sky130_fd_sc_hd__o21a_1
Xclkbuf_4_3_0_clk clknet_0_clk VGND VGND VPWR VPWR clknet_4_3_0_clk sky130_fd_sc_hd__clkbuf_8
X_615_ clknet_4_10_0_clk _065_ VGND VGND VPWR VPWR memory\[0\]\[1\] sky130_fd_sc_hd__dfxtp_1
XFILLER_35_130 VGND VGND VPWR VPWR sky130_fd_sc_hd__decap_3
X_400_ net144 net8 net48 VGND VGND VPWR VPWR _044_ sky130_fd_sc_hd__mux2_1
X_331_ net61 _237_ net67 VGND VGND VPWR VPWR _240_ sky130_fd_sc_hd__a21o_1
X_529_ _158_ _162_ _163_ _164_ VGND VGND VPWR VPWR net31 sky130_fd_sc_hd__o31a_1
XTAP_TAPCELL_ROW_27_191 VGND VPWR sky130_fd_sc_hd__tapvpwrvgnd_1
XTAP_TAPCELL_ROW_19_158 VGND VPWR sky130_fd_sc_hd__tapvpwrvgnd_1
XFILLER_37_225 VGND VGND VPWR VPWR sky130_fd_sc_hd__decap_3
XFILLER_36_85 VPWR VGND VPWR VGND sky130_ef_sc_hd__decap_12
XFILLER_36_41 VPWR VGND VPWR VGND sky130_ef_sc_hd__decap_12
XFILLER_35_6 VPWR VGND VPWR VGND sky130_ef_sc_hd__decap_12
Xinput16 mem_write_data[5] VGND VGND VPWR VPWR net16 sky130_fd_sc_hd__clkbuf_2
X_314_ net56 _222_ net66 VGND VGND VPWR VPWR _225_ sky130_fd_sc_hd__a21o_1
XFILLER_9_181 VGND VGND VPWR VPWR sky130_fd_sc_hd__fill_1
XFILLER_19_225 VGND VGND VPWR VPWR sky130_fd_sc_hd__decap_3
XTAP_TAPCELL_ROW_12_131 VGND VPWR sky130_fd_sc_hd__tapvpwrvgnd_1
XFILLER_0_3 VPWR VGND VPWR VGND sky130_ef_sc_hd__decap_12
XPHY_EDGE_ROW_5_Left_44 VGND VGND VPWR VPWR sky130_fd_sc_hd__decap_3
XFILLER_8_56 VGND VGND VPWR VPWR sky130_fd_sc_hd__decap_4
XTAP_TAPCELL_ROW_35_223 VGND VPWR sky130_fd_sc_hd__tapvpwrvgnd_1
XFILLER_33_3 VGND VGND VPWR VPWR sky130_fd_sc_hd__decap_8
XFILLER_6_195 VGND VGND VPWR VPWR sky130_fd_sc_hd__fill_1
XFILLER_17_87 VGND VGND VPWR VPWR sky130_fd_sc_hd__fill_1
XFILLER_3_121 VPWR VGND VPWR VGND sky130_ef_sc_hd__decap_12
Xhold5 memory\[6\]\[10\] VGND VGND VPWR VPWR net83 sky130_fd_sc_hd__dlygate4sd3_1
XFILLER_0_113 VPWR VGND VPWR VGND sky130_ef_sc_hd__decap_12
XFILLER_28_75 VGND VGND VPWR VPWR sky130_fd_sc_hd__fill_1
XFILLER_28_64 VGND VGND VPWR VPWR sky130_fd_sc_hd__decap_3
X_562_ clknet_4_5_0_clk _012_ VGND VGND VPWR VPWR memory\[5\]\[12\] sky130_fd_sc_hd__dfxtp_1
X_631_ clknet_4_11_0_clk _081_ VGND VGND VPWR VPWR memory\[6\]\[1\] sky130_fd_sc_hd__dfxtp_1
X_493_ net2 net3 VGND VGND VPWR VPWR _132_ sky130_fd_sc_hd__and2_1
XFILLER_36_109 VPWR VGND VPWR VGND sky130_ef_sc_hd__decap_12
X_614_ clknet_4_7_0_clk _064_ VGND VGND VPWR VPWR memory\[0\]\[0\] sky130_fd_sc_hd__dfxtp_1
XPHY_EDGE_ROW_34_Left_73 VGND VGND VPWR VPWR sky130_fd_sc_hd__decap_3
X_476_ net184 net14 net38 VGND VGND VPWR VPWR _115_ sky130_fd_sc_hd__mux2_1
XFILLER_30_54 VGND VGND VPWR VPWR sky130_fd_sc_hd__fill_2
X_545_ net59 _176_ net68 VGND VGND VPWR VPWR _179_ sky130_fd_sc_hd__a21o_1
XFILLER_14_22 VGND VGND VPWR VPWR sky130_fd_sc_hd__decap_6
XFILLER_35_197 VGND VGND VPWR VPWR sky130_fd_sc_hd__fill_1
XFILLER_26_175 VGND VGND VPWR VPWR sky130_fd_sc_hd__fill_2
X_330_ net57 _238_ VGND VGND VPWR VPWR _239_ sky130_fd_sc_hd__and2_1
X_459_ net121 net14 net41 VGND VGND VPWR VPWR _099_ sky130_fd_sc_hd__mux2_1
XFILLER_32_101 VGND VGND VPWR VPWR sky130_fd_sc_hd__fill_1
X_528_ net63 net14 net65 VGND VGND VPWR VPWR _164_ sky130_fd_sc_hd__o21a_1
XTAP_TAPCELL_ROW_27_192 VGND VPWR sky130_fd_sc_hd__tapvpwrvgnd_1
XTAP_TAPCELL_ROW_19_159 VGND VPWR sky130_fd_sc_hd__tapvpwrvgnd_1
XTAP_TAPCELL_ROW_2_90 VGND VPWR sky130_fd_sc_hd__tapvpwrvgnd_1
XFILLER_11_78 VGND VGND VPWR VPWR sky130_fd_sc_hd__decap_4
Xclkbuf_4_2_0_clk clknet_0_clk VGND VGND VPWR VPWR clknet_4_2_0_clk sky130_fd_sc_hd__clkbuf_8
XFILLER_36_97 VPWR VGND VPWR VGND sky130_ef_sc_hd__decap_12
XFILLER_36_53 VPWR VGND VPWR VGND sky130_ef_sc_hd__decap_12
Xinput17 mem_write_data[6] VGND VGND VPWR VPWR net17 sky130_fd_sc_hd__clkbuf_2
X_313_ net60 _219_ _223_ net54 VGND VGND VPWR VPWR _224_ sky130_fd_sc_hd__a22o_1
XPHY_EDGE_ROW_21_Left_60 VGND VGND VPWR VPWR sky130_fd_sc_hd__decap_3
XFILLER_22_22 VGND VGND VPWR VPWR sky130_fd_sc_hd__decap_6
XFILLER_7_119 VGND VGND VPWR VPWR sky130_fd_sc_hd__decap_4
XTAP_TAPCELL_ROW_35_224 VGND VPWR sky130_fd_sc_hd__tapvpwrvgnd_1
XTAP_TAPCELL_ROW_12_132 VGND VPWR sky130_fd_sc_hd__tapvpwrvgnd_1
XFILLER_33_65 VGND VGND VPWR VPWR sky130_fd_sc_hd__decap_8
Xhold6 memory\[2\]\[0\] VGND VGND VPWR VPWR net84 sky130_fd_sc_hd__dlygate4sd3_1
XFILLER_30_221 VGND VGND VPWR VPWR sky130_fd_sc_hd__decap_3
XFILLER_3_111 VGND VGND VPWR VPWR sky130_fd_sc_hd__fill_1
XFILLER_3_133 VGND VGND VPWR VPWR sky130_fd_sc_hd__decap_8
XFILLER_0_91 VGND VGND VPWR VPWR sky130_fd_sc_hd__decap_3
XPHY_EDGE_ROW_3_Right_3 VGND VGND VPWR VPWR sky130_fd_sc_hd__decap_3
X_492_ net60 _130_ net68 VGND VGND VPWR VPWR _131_ sky130_fd_sc_hd__a21o_1
X_630_ clknet_4_7_0_clk _080_ VGND VGND VPWR VPWR memory\[6\]\[0\] sky130_fd_sc_hd__dfxtp_1
XFILLER_0_169 VPWR VGND VPWR VGND sky130_ef_sc_hd__decap_12
XFILLER_0_147 VPWR VGND VPWR VGND sky130_ef_sc_hd__decap_12
XFILLER_0_125 VGND VGND VPWR VPWR sky130_fd_sc_hd__decap_8
X_561_ clknet_4_2_0_clk _011_ VGND VGND VPWR VPWR memory\[5\]\[11\] sky130_fd_sc_hd__dfxtp_1
X_613_ clknet_4_13_0_clk _063_ VGND VGND VPWR VPWR memory\[2\]\[15\] sky130_fd_sc_hd__dfxtp_1
X_544_ net56 _173_ _177_ net55 VGND VGND VPWR VPWR _178_ sky130_fd_sc_hd__a22o_1
X_475_ net155 net13 net38 VGND VGND VPWR VPWR _114_ sky130_fd_sc_hd__mux2_1
X_527_ net57 _159_ _161_ net61 VGND VGND VPWR VPWR _163_ sky130_fd_sc_hd__a22o_1
XTAP_TAPCELL_ROW_27_193 VGND VPWR sky130_fd_sc_hd__tapvpwrvgnd_1
X_389_ net176 net12 net48 VGND VGND VPWR VPWR _033_ sky130_fd_sc_hd__mux2_1
X_458_ net181 net13 net40 VGND VGND VPWR VPWR _098_ sky130_fd_sc_hd__mux2_1
XFILLER_2_15 VPWR VGND VPWR VGND sky130_ef_sc_hd__decap_12
XFILLER_23_146 VGND VGND VPWR VPWR sky130_fd_sc_hd__decap_8
XFILLER_11_57 VGND VGND VPWR VPWR sky130_fd_sc_hd__decap_4
XTAP_TAPCELL_ROW_2_91 VGND VPWR sky130_fd_sc_hd__tapvpwrvgnd_1
XFILLER_36_65 VPWR VGND VPWR VGND sky130_ef_sc_hd__decap_12
XFILLER_14_102 VGND VGND VPWR VPWR sky130_fd_sc_hd__fill_1
Xinput18 mem_write_data[7] VGND VGND VPWR VPWR net18 sky130_fd_sc_hd__clkbuf_2
X_312_ memory\[0\]\[11\] memory\[1\]\[11\] net69 VGND VGND VPWR VPWR _223_ sky130_fd_sc_hd__mux2_1
XFILLER_37_205 VGND VGND VPWR VPWR sky130_fd_sc_hd__decap_8
XFILLER_28_7 VGND VGND VPWR VPWR sky130_fd_sc_hd__decap_8
XTAP_TAPCELL_ROW_29_200 VGND VPWR sky130_fd_sc_hd__tapvpwrvgnd_1
XFILLER_28_227 VGND VGND VPWR VPWR sky130_fd_sc_hd__fill_1
XFILLER_22_56 VGND VGND VPWR VPWR sky130_fd_sc_hd__fill_2
XTAP_TAPCELL_ROW_21_166 VGND VPWR sky130_fd_sc_hd__tapvpwrvgnd_1
Xclkbuf_4_1_0_clk clknet_0_clk VGND VGND VPWR VPWR clknet_4_1_0_clk sky130_fd_sc_hd__clkbuf_8
XTAP_TAPCELL_ROW_12_133 VGND VPWR sky130_fd_sc_hd__tapvpwrvgnd_1
XFILLER_10_171 VGND VGND VPWR VPWR sky130_fd_sc_hd__fill_2
XFILLER_6_175 VGND VGND VPWR VPWR sky130_fd_sc_hd__decap_8
XTAP_TAPCELL_ROW_35_225 VGND VPWR sky130_fd_sc_hd__tapvpwrvgnd_1
XFILLER_33_55 VGND VGND VPWR VPWR sky130_fd_sc_hd__fill_1
Xhold7 memory\[2\]\[12\] VGND VGND VPWR VPWR net85 sky130_fd_sc_hd__dlygate4sd3_1
XFILLER_3_167 VGND VGND VPWR VPWR sky130_fd_sc_hd__fill_1
XFILLER_0_81 VGND VGND VPWR VPWR sky130_fd_sc_hd__decap_3
X_491_ memory\[4\]\[0\] memory\[5\]\[0\] net72 VGND VGND VPWR VPWR _130_ sky130_fd_sc_hd__mux2_1
X_560_ clknet_4_12_0_clk _010_ VGND VGND VPWR VPWR memory\[5\]\[10\] sky130_fd_sc_hd__dfxtp_1
XFILLER_0_159 VGND VGND VPWR VPWR sky130_fd_sc_hd__decap_8
XFILLER_0_104 VGND VGND VPWR VPWR sky130_fd_sc_hd__decap_4
XFILLER_5_15 VPWR VGND VPWR VGND sky130_ef_sc_hd__decap_12
XPHY_EDGE_ROW_22_Right_22 VGND VGND VPWR VPWR sky130_fd_sc_hd__decap_3
XPHY_EDGE_ROW_13_Right_13 VGND VGND VPWR VPWR sky130_fd_sc_hd__decap_3
XFILLER_38_141 VGND VGND VPWR VPWR sky130_fd_sc_hd__decap_8
XPHY_EDGE_ROW_31_Right_31 VGND VGND VPWR VPWR sky130_fd_sc_hd__decap_3
X_543_ memory\[0\]\[5\] memory\[1\]\[5\] net71 VGND VGND VPWR VPWR _177_ sky130_fd_sc_hd__mux2_1
X_474_ net153 net12 net38 VGND VGND VPWR VPWR _113_ sky130_fd_sc_hd__mux2_1
X_612_ clknet_4_2_0_clk _062_ VGND VGND VPWR VPWR memory\[2\]\[14\] sky130_fd_sc_hd__dfxtp_1
XFILLER_32_147 VGND VGND VPWR VPWR sky130_fd_sc_hd__decap_4
XFILLER_32_136 VGND VGND VPWR VPWR sky130_fd_sc_hd__decap_4
X_526_ net59 _160_ net68 VGND VGND VPWR VPWR _162_ sky130_fd_sc_hd__a21o_1
XFILLER_25_45 VGND VGND VPWR VPWR sky130_fd_sc_hd__decap_3
XFILLER_17_144 VGND VGND VPWR VPWR sky130_fd_sc_hd__fill_1
XFILLER_17_111 VGND VGND VPWR VPWR sky130_fd_sc_hd__fill_1
XFILLER_2_27 VGND VGND VPWR VPWR sky130_fd_sc_hd__fill_1
X_388_ net123 net5 net48 VGND VGND VPWR VPWR _032_ sky130_fd_sc_hd__mux2_1
X_457_ net178 net12 net40 VGND VGND VPWR VPWR _097_ sky130_fd_sc_hd__mux2_1
XTAP_TAPCELL_ROW_2_92 VGND VPWR sky130_fd_sc_hd__tapvpwrvgnd_1
XFILLER_36_77 VGND VGND VPWR VPWR sky130_fd_sc_hd__decap_6
Xinput19 mem_write_data[8] VGND VGND VPWR VPWR net19 sky130_fd_sc_hd__clkbuf_2
X_311_ memory\[2\]\[11\] memory\[3\]\[11\] net69 VGND VGND VPWR VPWR _222_ sky130_fd_sc_hd__mux2_1
XTAP_TAPCELL_ROW_15_142 VGND VPWR sky130_fd_sc_hd__tapvpwrvgnd_1
X_509_ net57 _141_ _145_ net54 VGND VGND VPWR VPWR _147_ sky130_fd_sc_hd__a22o_1
XFILLER_9_140 VGND VGND VPWR VPWR sky130_fd_sc_hd__decap_3
XTAP_TAPCELL_ROW_38_234 VGND VPWR sky130_fd_sc_hd__tapvpwrvgnd_1
XTAP_TAPCELL_ROW_21_167 VGND VPWR sky130_fd_sc_hd__tapvpwrvgnd_1
XTAP_TAPCELL_ROW_29_201 VGND VPWR sky130_fd_sc_hd__tapvpwrvgnd_1
XFILLER_6_165 VGND VGND VPWR VPWR sky130_fd_sc_hd__fill_2
Xhold8 memory\[6\]\[3\] VGND VGND VPWR VPWR net86 sky130_fd_sc_hd__dlygate4sd3_1
XFILLER_17_57 VGND VGND VPWR VPWR sky130_fd_sc_hd__fill_2
XPHY_EDGE_ROW_9_Left_48 VGND VGND VPWR VPWR sky130_fd_sc_hd__decap_3
XFILLER_2_190 VGND VGND VPWR VPWR sky130_fd_sc_hd__decap_6
X_490_ net2 net3 VGND VGND VPWR VPWR _129_ sky130_fd_sc_hd__and2b_1
Xclkbuf_4_0_0_clk clknet_0_clk VGND VGND VPWR VPWR clknet_4_0_0_clk sky130_fd_sc_hd__clkbuf_8
XFILLER_5_27 VGND VGND VPWR VPWR sky130_fd_sc_hd__decap_6
XFILLER_38_197 VPWR VGND VPWR VGND sky130_ef_sc_hd__decap_12
XFILLER_29_186 VGND VGND VPWR VPWR sky130_fd_sc_hd__decap_3
X_473_ net164 net5 net39 VGND VGND VPWR VPWR _112_ sky130_fd_sc_hd__mux2_1
X_542_ memory\[6\]\[5\] memory\[7\]\[5\] net72 VGND VGND VPWR VPWR _176_ sky130_fd_sc_hd__mux2_1
X_611_ clknet_4_11_0_clk _061_ VGND VGND VPWR VPWR memory\[2\]\[13\] sky130_fd_sc_hd__dfxtp_1
XFILLER_35_156 VPWR VGND VPWR VGND sky130_ef_sc_hd__decap_12
XPHY_EDGE_ROW_38_Left_77 VGND VGND VPWR VPWR sky130_fd_sc_hd__decap_3
XFILLER_9_3 VGND VGND VPWR VPWR sky130_fd_sc_hd__fill_2
X_456_ net195 net5 net40 VGND VGND VPWR VPWR _096_ sky130_fd_sc_hd__mux2_1
XFILLER_32_126 VGND VGND VPWR VPWR sky130_fd_sc_hd__decap_4
X_525_ memory\[4\]\[3\] memory\[5\]\[3\] net77 VGND VGND VPWR VPWR _161_ sky130_fd_sc_hd__mux2_1
X_387_ net72 net67 net56 VGND VGND VPWR VPWR _261_ sky130_fd_sc_hd__and3_1
XTAP_TAPCELL_ROW_2_93 VGND VPWR sky130_fd_sc_hd__tapvpwrvgnd_1
XFILLER_14_159 VGND VGND VPWR VPWR sky130_fd_sc_hd__fill_1
X_310_ net58 _220_ VGND VGND VPWR VPWR _221_ sky130_fd_sc_hd__and2_1
X_439_ net89 net5 net43 VGND VGND VPWR VPWR _080_ sky130_fd_sc_hd__mux2_1
XTAP_TAPCELL_ROW_15_143 VGND VPWR sky130_fd_sc_hd__tapvpwrvgnd_1
X_508_ net61 _144_ net67 VGND VGND VPWR VPWR _146_ sky130_fd_sc_hd__a21o_1
XTAP_TAPCELL_ROW_38_235 VGND VPWR sky130_fd_sc_hd__tapvpwrvgnd_1
XTAP_TAPCELL_ROW_21_168 VGND VPWR sky130_fd_sc_hd__tapvpwrvgnd_1
XFILLER_11_107 VGND VGND VPWR VPWR sky130_fd_sc_hd__decap_4
XFILLER_9_163 VGND VGND VPWR VPWR sky130_fd_sc_hd__decap_4
XFILLER_33_221 VGND VGND VPWR VPWR sky130_fd_sc_hd__decap_3
XPHY_EDGE_ROW_25_Left_64 VGND VGND VPWR VPWR sky130_fd_sc_hd__decap_3
Xhold9 memory\[4\]\[3\] VGND VGND VPWR VPWR net87 sky130_fd_sc_hd__dlygate4sd3_1
XFILLER_24_3 VGND VGND VPWR VPWR sky130_fd_sc_hd__decap_6
XFILLER_9_81 VGND VGND VPWR VPWR sky130_fd_sc_hd__fill_1
XFILLER_8_206 VGND VGND VPWR VPWR sky130_fd_sc_hd__fill_1
XFILLER_38_154 VPWR VGND VPWR VGND sky130_ef_sc_hd__decap_12
XPHY_EDGE_ROW_7_Right_7 VGND VGND VPWR VPWR sky130_fd_sc_hd__decap_3
X_610_ clknet_4_4_0_clk _060_ VGND VGND VPWR VPWR memory\[2\]\[12\] sky130_fd_sc_hd__dfxtp_1
X_541_ net60 _174_ VGND VGND VPWR VPWR _175_ sky130_fd_sc_hd__and2_1
X_472_ net70 net66 net58 VGND VGND VPWR VPWR _266_ sky130_fd_sc_hd__and3_1
XPHY_EDGE_ROW_12_Left_51 VGND VGND VPWR VPWR sky130_fd_sc_hd__decap_3
XFILLER_26_102 VGND VGND VPWR VPWR sky130_fd_sc_hd__fill_2
XFILLER_1_223 VGND VGND VPWR VPWR sky130_fd_sc_hd__fill_1
X_524_ memory\[6\]\[3\] memory\[7\]\[3\] net77 VGND VGND VPWR VPWR _160_ sky130_fd_sc_hd__mux2_1
X_386_ net90 net11 net51 VGND VGND VPWR VPWR _031_ sky130_fd_sc_hd__mux2_1
X_455_ net73 net66 net54 VGND VGND VPWR VPWR _265_ sky130_fd_sc_hd__and3_1
XFILLER_2_29 VPWR VGND VPWR VGND sky130_ef_sc_hd__decap_12
XFILLER_14_138 VGND VGND VPWR VPWR sky130_fd_sc_hd__fill_2
XTAP_TAPCELL_ROW_9_120 VGND VPWR sky130_fd_sc_hd__tapvpwrvgnd_1
XTAP_TAPCELL_ROW_38_236 VGND VPWR sky130_fd_sc_hd__tapvpwrvgnd_1
X_369_ net198 net11 net53 VGND VGND VPWR VPWR _015_ sky130_fd_sc_hd__mux2_1
XTAP_TAPCELL_ROW_15_144 VGND VPWR sky130_fd_sc_hd__tapvpwrvgnd_1
X_438_ net73 net66 net58 VGND VGND VPWR VPWR _264_ sky130_fd_sc_hd__and3b_1
X_507_ memory\[0\]\[1\] memory\[1\]\[1\] net75 VGND VGND VPWR VPWR _145_ sky130_fd_sc_hd__mux2_1
XTAP_TAPCELL_ROW_21_169 VGND VPWR sky130_fd_sc_hd__tapvpwrvgnd_1
XFILLER_10_141 VGND VGND VPWR VPWR sky130_fd_sc_hd__fill_2
XFILLER_33_200 VGND VGND VPWR VPWR sky130_fd_sc_hd__fill_1
XFILLER_10_163 VGND VGND VPWR VPWR sky130_fd_sc_hd__decap_8
XFILLER_33_36 VGND VGND VPWR VPWR sky130_fd_sc_hd__decap_3
XFILLER_15_222 VGND VGND VPWR VPWR sky130_fd_sc_hd__fill_2
XFILLER_28_25 VGND VGND VPWR VPWR sky130_fd_sc_hd__decap_3
XFILLER_21_225 VGND VGND VPWR VPWR sky130_fd_sc_hd__decap_3
XFILLER_17_3 VGND VGND VPWR VPWR sky130_fd_sc_hd__decap_3
XFILLER_0_51 VGND VGND VPWR VPWR sky130_fd_sc_hd__fill_1
XFILLER_38_166 VGND VGND VPWR VPWR sky130_fd_sc_hd__fill_2
XFILLER_38_133 VGND VGND VPWR VPWR sky130_fd_sc_hd__decap_3
XFILLER_38_111 VGND VGND VPWR VPWR sky130_fd_sc_hd__fill_1
X_471_ net202 net11 net41 VGND VGND VPWR VPWR _111_ sky130_fd_sc_hd__mux2_1
XFILLER_29_122 VGND VGND VPWR VPWR sky130_fd_sc_hd__fill_2
X_540_ memory\[4\]\[5\] memory\[5\]\[5\] net71 VGND VGND VPWR VPWR _174_ sky130_fd_sc_hd__mux2_1
XFILLER_35_169 VPWR VGND VPWR VGND sky130_ef_sc_hd__decap_12
XFILLER_20_81 VGND VGND VPWR VPWR sky130_fd_sc_hd__decap_3
Xhold90 memory\[7\]\[7\] VGND VGND VPWR VPWR net168 sky130_fd_sc_hd__dlygate4sd3_1
X_669_ clknet_4_3_0_clk _119_ VGND VGND VPWR VPWR memory\[7\]\[7\] sky130_fd_sc_hd__dfxtp_1
X_523_ memory\[2\]\[3\] memory\[3\]\[3\] net77 VGND VGND VPWR VPWR _159_ sky130_fd_sc_hd__mux2_1
X_454_ net94 net11 net43 VGND VGND VPWR VPWR _095_ sky130_fd_sc_hd__mux2_1
X_385_ net128 net10 net50 VGND VGND VPWR VPWR _030_ sky130_fd_sc_hd__mux2_1
XTAP_TAPCELL_ROW_24_178 VGND VPWR sky130_fd_sc_hd__tapvpwrvgnd_1
XTAP_TAPCELL_ROW_9_121 VGND VPWR sky130_fd_sc_hd__tapvpwrvgnd_1
XTAP_TAPCELL_ROW_38_237 VGND VPWR sky130_fd_sc_hd__tapvpwrvgnd_1
X_437_ net11 net189 net45 VGND VGND VPWR VPWR _079_ sky130_fd_sc_hd__mux2_1
X_299_ net62 net20 VGND VGND VPWR VPWR _212_ sky130_fd_sc_hd__or2_1
XTAP_TAPCELL_ROW_15_145 VGND VPWR sky130_fd_sc_hd__tapvpwrvgnd_1
X_506_ memory\[4\]\[1\] memory\[5\]\[1\] net75 VGND VGND VPWR VPWR _144_ sky130_fd_sc_hd__mux2_1
XFILLER_13_150 VGND VGND VPWR VPWR sky130_fd_sc_hd__fill_2
XFILLER_3_62 VGND VGND VPWR VPWR sky130_fd_sc_hd__fill_1
XFILLER_3_95 VGND VGND VPWR VPWR sky130_fd_sc_hd__fill_1
X_368_ net117 net10 net52 VGND VGND VPWR VPWR _014_ sky130_fd_sc_hd__mux2_1
XPHY_EDGE_ROW_29_Right_29 VGND VGND VPWR VPWR sky130_fd_sc_hd__decap_3
XPHY_EDGE_ROW_38_Right_38 VGND VGND VPWR VPWR sky130_fd_sc_hd__decap_3
XFILLER_12_60 VGND VGND VPWR VPWR sky130_fd_sc_hd__fill_2
XFILLER_8_29 VGND VGND VPWR VPWR sky130_fd_sc_hd__fill_2
XFILLER_23_92 VGND VGND VPWR VPWR sky130_fd_sc_hd__decap_4
XFILLER_3_105 VGND VGND VPWR VPWR sky130_fd_sc_hd__decap_6
XFILLER_0_85 VGND VGND VPWR VPWR sky130_fd_sc_hd__fill_2
XFILLER_9_61 VGND VGND VPWR VPWR sky130_fd_sc_hd__fill_1
XFILLER_28_15 VGND VGND VPWR VPWR sky130_fd_sc_hd__fill_2
XFILLER_18_81 VGND VGND VPWR VPWR sky130_fd_sc_hd__decap_3
Xhold91 memory\[3\]\[15\] VGND VGND VPWR VPWR net169 sky130_fd_sc_hd__dlygate4sd3_1
XFILLER_35_104 VGND VGND VPWR VPWR sky130_fd_sc_hd__fill_2
Xhold80 memory\[5\]\[3\] VGND VGND VPWR VPWR net158 sky130_fd_sc_hd__dlygate4sd3_1
XFILLER_29_91 VGND VGND VPWR VPWR sky130_fd_sc_hd__fill_1
XFILLER_20_71 VGND VGND VPWR VPWR sky130_fd_sc_hd__decap_4
XFILLER_20_60 VGND VGND VPWR VPWR sky130_fd_sc_hd__fill_2
X_599_ clknet_4_10_0_clk _049_ VGND VGND VPWR VPWR memory\[2\]\[1\] sky130_fd_sc_hd__dfxtp_1
X_668_ clknet_4_10_0_clk _118_ VGND VGND VPWR VPWR memory\[7\]\[6\] sky130_fd_sc_hd__dfxtp_1
X_470_ net100 net10 net40 VGND VGND VPWR VPWR _110_ sky130_fd_sc_hd__mux2_1
XFILLER_34_170 VGND VGND VPWR VPWR sky130_fd_sc_hd__fill_1
XFILLER_25_27 VGND VGND VPWR VPWR sky130_fd_sc_hd__fill_2
X_522_ net55 _157_ VGND VGND VPWR VPWR _158_ sky130_fd_sc_hd__and2_1
X_384_ net101 net9 net51 VGND VGND VPWR VPWR _029_ sky130_fd_sc_hd__mux2_1
XFILLER_1_225 VGND VGND VPWR VPWR sky130_fd_sc_hd__decap_3
X_453_ net149 net10 net42 VGND VGND VPWR VPWR _094_ sky130_fd_sc_hd__mux2_1
XTAP_TAPCELL_ROW_18_154 VGND VPWR sky130_fd_sc_hd__tapvpwrvgnd_1
XFILLER_16_170 VPWR VGND VPWR VGND sky130_ef_sc_hd__decap_12
XFILLER_36_15 VPWR VGND VPWR VGND sky130_ef_sc_hd__decap_12
XTAP_TAPCELL_ROW_24_179 VGND VPWR sky130_fd_sc_hd__tapvpwrvgnd_1
XFILLER_7_3 VPWR VGND VPWR VGND sky130_ef_sc_hd__decap_12
X_367_ net125 net9 net53 VGND VGND VPWR VPWR _013_ sky130_fd_sc_hd__mux2_1
X_298_ net60 _207_ _210_ net59 VGND VGND VPWR VPWR _211_ sky130_fd_sc_hd__a22o_1
X_505_ net58 _142_ VGND VGND VPWR VPWR _143_ sky130_fd_sc_hd__and2_1
X_436_ net10 net174 net44 VGND VGND VPWR VPWR _078_ sky130_fd_sc_hd__mux2_1
XFILLER_9_177 VGND VGND VPWR VPWR sky130_fd_sc_hd__decap_4
XTAP_TAPCELL_ROW_38_238 VGND VPWR sky130_fd_sc_hd__tapvpwrvgnd_1
XFILLER_36_221 VGND VGND VPWR VPWR sky130_fd_sc_hd__decap_6
X_419_ net190 net10 net46 VGND VGND VPWR VPWR _062_ sky130_fd_sc_hd__mux2_1
XFILLER_31_7 VPWR VGND VPWR VGND sky130_ef_sc_hd__decap_12
XPHY_EDGE_ROW_29_Left_68 VGND VGND VPWR VPWR sky130_fd_sc_hd__decap_3
Xclkbuf_4_15_0_clk clknet_0_clk VGND VGND VPWR VPWR clknet_4_15_0_clk sky130_fd_sc_hd__clkbuf_8
XFILLER_38_113 VPWR VGND VPWR VGND sky130_ef_sc_hd__decap_12
Xhold70 memory\[3\]\[3\] VGND VGND VPWR VPWR net148 sky130_fd_sc_hd__dlygate4sd3_1
Xhold81 memory\[1\]\[5\] VGND VGND VPWR VPWR net159 sky130_fd_sc_hd__dlygate4sd3_1
Xhold92 memory\[0\]\[7\] VGND VGND VPWR VPWR net170 sky130_fd_sc_hd__dlygate4sd3_1
X_598_ clknet_4_7_0_clk _048_ VGND VGND VPWR VPWR memory\[2\]\[0\] sky130_fd_sc_hd__dfxtp_1
XFILLER_26_149 VGND VGND VPWR VPWR sky130_fd_sc_hd__fill_1
X_667_ clknet_4_6_0_clk _117_ VGND VGND VPWR VPWR memory\[7\]\[5\] sky130_fd_sc_hd__dfxtp_1
XPHY_EDGE_ROW_16_Left_55 VGND VGND VPWR VPWR sky130_fd_sc_hd__decap_3
XFILLER_6_85 VGND VGND VPWR VPWR sky130_fd_sc_hd__fill_2
X_521_ memory\[0\]\[3\] memory\[1\]\[3\] net77 VGND VGND VPWR VPWR _157_ sky130_fd_sc_hd__mux2_1
X_383_ net132 net8 net50 VGND VGND VPWR VPWR _028_ sky130_fd_sc_hd__mux2_1
X_452_ net103 net9 net42 VGND VGND VPWR VPWR _093_ sky130_fd_sc_hd__mux2_1
XTAP_TAPCELL_ROW_18_155 VGND VPWR sky130_fd_sc_hd__tapvpwrvgnd_1
XFILLER_16_182 VGND VGND VPWR VPWR sky130_fd_sc_hd__decap_4
XFILLER_15_61 VGND VGND VPWR VPWR sky130_fd_sc_hd__fill_1
XFILLER_36_27 VGND VGND VPWR VPWR sky130_fd_sc_hd__fill_1
XFILLER_22_130 VGND VGND VPWR VPWR sky130_fd_sc_hd__fill_2
X_366_ net193 net8 net52 VGND VGND VPWR VPWR _012_ sky130_fd_sc_hd__mux2_1
X_435_ net9 net162 net44 VGND VGND VPWR VPWR _077_ sky130_fd_sc_hd__mux2_1
X_297_ memory\[6\]\[9\] memory\[7\]\[9\] net69 VGND VGND VPWR VPWR _210_ sky130_fd_sc_hd__mux2_1
X_504_ memory\[6\]\[1\] memory\[7\]\[1\] net75 VGND VGND VPWR VPWR _142_ sky130_fd_sc_hd__mux2_1
XFILLER_9_167 VGND VGND VPWR VPWR sky130_fd_sc_hd__fill_1
XTAP_TAPCELL_ROW_38_239 VGND VPWR sky130_fd_sc_hd__tapvpwrvgnd_1
XFILLER_22_29 VGND VGND VPWR VPWR sky130_fd_sc_hd__fill_2
XFILLER_37_81 VPWR VGND VPWR VGND sky130_ef_sc_hd__decap_12
XFILLER_33_225 VGND VGND VPWR VPWR sky130_fd_sc_hd__decap_3
X_349_ net59 _254_ net67 VGND VGND VPWR VPWR _256_ sky130_fd_sc_hd__a21o_1
X_418_ net112 net9 net47 VGND VGND VPWR VPWR _061_ sky130_fd_sc_hd__mux2_1
XTAP_TAPCELL_ROW_34_220 VGND VPWR sky130_fd_sc_hd__tapvpwrvgnd_1
XFILLER_15_225 VGND VGND VPWR VPWR sky130_fd_sc_hd__decap_3
XFILLER_0_98 VGND VGND VPWR VPWR sky130_fd_sc_hd__decap_3
XPHY_EDGE_ROW_4_Left_43 VGND VGND VPWR VPWR sky130_fd_sc_hd__decap_3
XFILLER_12_206 VGND VGND VPWR VPWR sky130_fd_sc_hd__fill_2
XFILLER_34_82 VGND VGND VPWR VPWR sky130_fd_sc_hd__fill_2
XPHY_EDGE_ROW_30_Left_69 VGND VGND VPWR VPWR sky130_fd_sc_hd__decap_3
XFILLER_38_169 VPWR VGND VPWR VGND sky130_ef_sc_hd__decap_12
XFILLER_38_125 VGND VGND VPWR VPWR sky130_fd_sc_hd__decap_8
XFILLER_15_3 VGND VGND VPWR VPWR sky130_fd_sc_hd__decap_8
XFILLER_29_169 VGND VGND VPWR VPWR sky130_fd_sc_hd__fill_1
X_597_ clknet_4_13_0_clk _047_ VGND VGND VPWR VPWR memory\[3\]\[15\] sky130_fd_sc_hd__dfxtp_1
X_666_ clknet_4_7_0_clk _116_ VGND VGND VPWR VPWR memory\[7\]\[4\] sky130_fd_sc_hd__dfxtp_1
XFILLER_28_191 VGND VGND VPWR VPWR sky130_fd_sc_hd__decap_4
Xclkbuf_4_14_0_clk clknet_0_clk VGND VGND VPWR VPWR clknet_4_14_0_clk sky130_fd_sc_hd__clkbuf_8
Xhold82 memory\[3\]\[11\] VGND VGND VPWR VPWR net160 sky130_fd_sc_hd__dlygate4sd3_1
Xhold71 memory\[6\]\[14\] VGND VGND VPWR VPWR net149 sky130_fd_sc_hd__dlygate4sd3_1
Xhold93 memory\[3\]\[6\] VGND VGND VPWR VPWR net171 sky130_fd_sc_hd__dlygate4sd3_1
Xhold60 memory\[2\]\[2\] VGND VGND VPWR VPWR net138 sky130_fd_sc_hd__dlygate4sd3_1
XFILLER_19_191 VGND VGND VPWR VPWR sky130_fd_sc_hd__decap_4
X_520_ _151_ _154_ _155_ _156_ VGND VGND VPWR VPWR net30 sky130_fd_sc_hd__o31a_1
X_649_ clknet_4_15_0_clk _099_ VGND VGND VPWR VPWR memory\[1\]\[3\] sky130_fd_sc_hd__dfxtp_1
XPHY_EDGE_ROW_33_Left_72 VGND VGND VPWR VPWR sky130_fd_sc_hd__decap_3
X_451_ net113 net8 net43 VGND VGND VPWR VPWR _092_ sky130_fd_sc_hd__mux2_1
XTAP_TAPCELL_ROW_18_156 VGND VPWR sky130_fd_sc_hd__tapvpwrvgnd_1
X_382_ net82 net7 net50 VGND VGND VPWR VPWR _027_ sky130_fd_sc_hd__mux2_1
XFILLER_31_164 VGND VGND VPWR VPWR sky130_fd_sc_hd__decap_4
X_434_ net8 net183 net45 VGND VGND VPWR VPWR _076_ sky130_fd_sc_hd__mux2_1
X_296_ net56 _208_ VGND VGND VPWR VPWR _209_ sky130_fd_sc_hd__and2_1
X_503_ memory\[2\]\[1\] memory\[3\]\[1\] net75 VGND VGND VPWR VPWR _141_ sky130_fd_sc_hd__mux2_1
X_365_ net122 net7 net52 VGND VGND VPWR VPWR _011_ sky130_fd_sc_hd__mux2_1
XFILLER_9_135 VGND VGND VPWR VPWR sky130_fd_sc_hd__fill_1
XFILLER_27_223 VGND VGND VPWR VPWR sky130_fd_sc_hd__fill_1
XTAP_TAPCELL_ROW_20_162 VGND VPWR sky130_fd_sc_hd__tapvpwrvgnd_1
XFILLER_10_101 VGND VGND VPWR VPWR sky130_fd_sc_hd__decap_4
XFILLER_37_93 VPWR VGND VPWR VGND sky130_ef_sc_hd__decap_12
X_348_ memory\[4\]\[15\] memory\[5\]\[15\] net76 VGND VGND VPWR VPWR _255_ sky130_fd_sc_hd__mux2_1
X_417_ net85 net8 net46 VGND VGND VPWR VPWR _060_ sky130_fd_sc_hd__mux2_1
XPHY_EDGE_ROW_25_Right_25 VGND VGND VPWR VPWR sky130_fd_sc_hd__decap_3
XPHY_EDGE_ROW_16_Right_16 VGND VGND VPWR VPWR sky130_fd_sc_hd__decap_3
X_279_ net58 _192_ net66 VGND VGND VPWR VPWR _194_ sky130_fd_sc_hd__a21o_1
XPHY_EDGE_ROW_34_Right_34 VGND VGND VPWR VPWR sky130_fd_sc_hd__decap_3
XTAP_TAPCELL_ROW_34_221 VGND VPWR sky130_fd_sc_hd__tapvpwrvgnd_1
XFILLER_23_84 VGND VGND VPWR VPWR sky130_fd_sc_hd__decap_4
XFILLER_37_181 VPWR VGND VPWR VGND sky130_ef_sc_hd__decap_12
XFILLER_29_137 VGND VGND VPWR VPWR sky130_fd_sc_hd__decap_4
XPHY_EDGE_ROW_2_Right_2 VGND VGND VPWR VPWR sky130_fd_sc_hd__decap_3
XFILLER_4_214 VGND VGND VPWR VPWR sky130_fd_sc_hd__fill_2
X_665_ clknet_4_15_0_clk _115_ VGND VGND VPWR VPWR memory\[7\]\[3\] sky130_fd_sc_hd__dfxtp_1
XFILLER_29_83 VGND VGND VPWR VPWR sky130_fd_sc_hd__decap_8
Xhold94 memory\[1\]\[12\] VGND VGND VPWR VPWR net172 sky130_fd_sc_hd__dlygate4sd3_1
Xhold61 memory\[7\]\[13\] VGND VGND VPWR VPWR net139 sky130_fd_sc_hd__dlygate4sd3_1
Xhold72 memory\[3\]\[14\] VGND VGND VPWR VPWR net150 sky130_fd_sc_hd__dlygate4sd3_1
Xhold50 memory\[4\]\[14\] VGND VGND VPWR VPWR net128 sky130_fd_sc_hd__dlygate4sd3_1
X_596_ clknet_4_2_0_clk _046_ VGND VGND VPWR VPWR memory\[3\]\[14\] sky130_fd_sc_hd__dfxtp_1
Xhold83 memory\[1\]\[6\] VGND VGND VPWR VPWR net161 sky130_fd_sc_hd__dlygate4sd3_1
XFILLER_34_195 VGND VGND VPWR VPWR sky130_fd_sc_hd__fill_1
XFILLER_26_118 VGND VGND VPWR VPWR sky130_fd_sc_hd__fill_2
XFILLER_31_40 VGND VGND VPWR VPWR sky130_fd_sc_hd__decap_4
X_381_ net131 net6 net51 VGND VGND VPWR VPWR _026_ sky130_fd_sc_hd__mux2_1
X_450_ net185 net7 net42 VGND VGND VPWR VPWR _091_ sky130_fd_sc_hd__mux2_1
XTAP_TAPCELL_ROW_18_157 VGND VPWR sky130_fd_sc_hd__tapvpwrvgnd_1
X_579_ clknet_4_11_0_clk _029_ VGND VGND VPWR VPWR memory\[4\]\[13\] sky130_fd_sc_hd__dfxtp_1
X_648_ clknet_4_10_0_clk _098_ VGND VGND VPWR VPWR memory\[1\]\[2\] sky130_fd_sc_hd__dfxtp_1
X_502_ _131_ _134_ _139_ _140_ net64 VGND VGND VPWR VPWR net22 sky130_fd_sc_hd__o311a_1
Xclkbuf_4_13_0_clk clknet_0_clk VGND VGND VPWR VPWR clknet_4_13_0_clk sky130_fd_sc_hd__clkbuf_8
X_433_ net7 net191 net44 VGND VGND VPWR VPWR _075_ sky130_fd_sc_hd__mux2_1
X_364_ net187 net6 net53 VGND VGND VPWR VPWR _010_ sky130_fd_sc_hd__mux2_1
X_295_ memory\[2\]\[9\] memory\[3\]\[9\] net70 VGND VGND VPWR VPWR _208_ sky130_fd_sc_hd__mux2_1
XFILLER_3_44 VPWR VGND VPWR VGND sky130_ef_sc_hd__decap_12
XTAP_TAPCELL_ROW_37_230 VGND VPWR sky130_fd_sc_hd__tapvpwrvgnd_1
XTAP_TAPCELL_ROW_6_106 VGND VPWR sky130_fd_sc_hd__tapvpwrvgnd_1
X_347_ memory\[6\]\[15\] memory\[7\]\[15\] net76 VGND VGND VPWR VPWR _254_ sky130_fd_sc_hd__mux2_1
XTAP_TAPCELL_ROW_20_163 VGND VPWR sky130_fd_sc_hd__tapvpwrvgnd_1
XFILLER_5_3 VPWR VGND VPWR VGND sky130_ef_sc_hd__decap_12
XFILLER_6_139 VGND VGND VPWR VPWR sky130_fd_sc_hd__fill_1
X_416_ net137 net7 net46 VGND VGND VPWR VPWR _059_ sky130_fd_sc_hd__mux2_1
X_278_ memory\[2\]\[7\] memory\[3\]\[7\] net70 VGND VGND VPWR VPWR _193_ sky130_fd_sc_hd__mux2_1
XFILLER_38_3 VPWR VGND VPWR VGND sky130_ef_sc_hd__decap_12
XFILLER_24_227 VGND VGND VPWR VPWR sky130_fd_sc_hd__fill_1
XFILLER_5_161 VGND VGND VPWR VPWR sky130_fd_sc_hd__decap_6
XFILLER_18_63 VGND VGND VPWR VPWR sky130_fd_sc_hd__decap_4
XFILLER_38_149 VGND VGND VPWR VPWR sky130_fd_sc_hd__fill_1
XFILLER_38_105 VGND VGND VPWR VPWR sky130_fd_sc_hd__decap_6
XFILLER_34_62 VPWR VGND VPWR VGND sky130_ef_sc_hd__decap_12
XFILLER_7_223 VGND VGND VPWR VPWR sky130_fd_sc_hd__fill_1
XFILLER_37_193 VPWR VGND VPWR VGND sky130_ef_sc_hd__decap_12
Xhold73 memory\[0\]\[4\] VGND VGND VPWR VPWR net151 sky130_fd_sc_hd__dlygate4sd3_1
Xhold84 memory\[0\]\[13\] VGND VGND VPWR VPWR net162 sky130_fd_sc_hd__dlygate4sd3_1
Xhold51 memory\[7\]\[9\] VGND VGND VPWR VPWR net129 sky130_fd_sc_hd__dlygate4sd3_1
X_595_ clknet_4_11_0_clk _045_ VGND VGND VPWR VPWR memory\[3\]\[13\] sky130_fd_sc_hd__dfxtp_1
Xhold62 memory\[1\]\[9\] VGND VGND VPWR VPWR net140 sky130_fd_sc_hd__dlygate4sd3_1
X_664_ clknet_4_8_0_clk _114_ VGND VGND VPWR VPWR memory\[7\]\[2\] sky130_fd_sc_hd__dfxtp_1
Xhold40 memory\[5\]\[2\] VGND VGND VPWR VPWR net118 sky130_fd_sc_hd__dlygate4sd3_1
Xhold95 memory\[3\]\[7\] VGND VGND VPWR VPWR net173 sky130_fd_sc_hd__dlygate4sd3_1
XFILLER_20_3 VGND VGND VPWR VPWR sky130_fd_sc_hd__decap_3
XFILLER_6_33 VGND VGND VPWR VPWR sky130_fd_sc_hd__fill_1
X_380_ net106 net20 net50 VGND VGND VPWR VPWR _025_ sky130_fd_sc_hd__mux2_1
XFILLER_1_207 VPWR VGND VPWR VGND sky130_ef_sc_hd__decap_12
Xoutput30 net30 VGND VGND VPWR VPWR mem_read_data[2] sky130_fd_sc_hd__buf_2
XFILLER_31_111 VGND VGND VPWR VPWR sky130_fd_sc_hd__fill_1
X_578_ clknet_4_5_0_clk _028_ VGND VGND VPWR VPWR memory\[4\]\[12\] sky130_fd_sc_hd__dfxtp_1
X_647_ clknet_4_11_0_clk _097_ VGND VGND VPWR VPWR memory\[1\]\[1\] sky130_fd_sc_hd__dfxtp_1
.ends
