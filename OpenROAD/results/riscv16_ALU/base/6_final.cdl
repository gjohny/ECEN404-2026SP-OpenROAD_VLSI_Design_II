* CDL Netlist generated by OpenROAD

*.BUSDELIMITER [

.SUBCKT ALU ALU_control[0] ALU_control[1] ALU_control[2] ALU_control[3]
+ ALU_result[0] ALU_result[10] ALU_result[11] ALU_result[12]
+ ALU_result[13] ALU_result[14] ALU_result[15] ALU_result[1]
+ ALU_result[2] ALU_result[3] ALU_result[4] ALU_result[5] ALU_result[6]
+ ALU_result[7] ALU_result[8] ALU_result[9] SrcA[0] SrcA[10]
+ SrcA[11] SrcA[12] SrcA[13] SrcA[14] SrcA[15] SrcA[1] SrcA[2]
+ SrcA[3] SrcA[4] SrcA[5] SrcA[6] SrcA[7] SrcA[8] SrcA[9] SrcB[0]
+ SrcB[10] SrcB[11] SrcB[12] SrcB[13] SrcB[14] SrcB[15] SrcB[1]
+ SrcB[2] SrcB[3] SrcB[4] SrcB[5] SrcB[6] SrcB[7] SrcB[8] SrcB[9]
+ zero VSS VDD
XTAP_TAPCELL_ROW_12_54 VSS VDD sky130_fd_sc_hd__tapvpwrvgnd_1
X_0636_ net59 VSS VSS VDD VDD _0132_ sky130_fd_sc_hd__inv_1
XTAP_TAPCELL_ROW_12_53 VSS VDD sky130_fd_sc_hd__tapvpwrvgnd_1
XTAP_TAPCELL_ROW_12_52 VSS VDD sky130_fd_sc_hd__tapvpwrvgnd_1
XTAP_TAPCELL_ROW_11_51 VSS VDD sky130_fd_sc_hd__tapvpwrvgnd_1
XTAP_TAPCELL_ROW_11_50 VSS VDD sky130_fd_sc_hd__tapvpwrvgnd_1
X_0641_ net61 VSS VSS VDD VDD _0012_ sky130_fd_sc_hd__inv_1
XTAP_TAPCELL_ROW_11_49 VSS VDD sky130_fd_sc_hd__tapvpwrvgnd_1
XTAP_TAPCELL_ROW_11_48 VSS VDD sky130_fd_sc_hd__tapvpwrvgnd_1
XTAP_TAPCELL_ROW_10_47 VSS VDD sky130_fd_sc_hd__tapvpwrvgnd_1
XTAP_TAPCELL_ROW_10_46 VSS VDD sky130_fd_sc_hd__tapvpwrvgnd_1
XTAP_TAPCELL_ROW_10_45 VSS VDD sky130_fd_sc_hd__tapvpwrvgnd_1
XTAP_TAPCELL_ROW_10_44 VSS VDD sky130_fd_sc_hd__tapvpwrvgnd_1
XTAP_TAPCELL_ROW_9_43 VSS VDD sky130_fd_sc_hd__tapvpwrvgnd_1
XTAP_TAPCELL_ROW_9_42 VSS VDD sky130_fd_sc_hd__tapvpwrvgnd_1
XTAP_TAPCELL_ROW_9_41 VSS VDD sky130_fd_sc_hd__tapvpwrvgnd_1
XTAP_TAPCELL_ROW_9_40 VSS VDD sky130_fd_sc_hd__tapvpwrvgnd_1
XTAP_TAPCELL_ROW_8_39 VSS VDD sky130_fd_sc_hd__tapvpwrvgnd_1
XTAP_TAPCELL_ROW_8_38 VSS VDD sky130_fd_sc_hd__tapvpwrvgnd_1
X_0654_ net2 net3 net4 VSS VSS VDD VDD _0148_ sky130_fd_sc_hd__nor3_2
XTAP_TAPCELL_ROW_8_37 VSS VDD sky130_fd_sc_hd__tapvpwrvgnd_1
X_0656_ net63 _0148_ VSS VSS VDD VDD _0150_ sky130_fd_sc_hd__nand2_1
X_0657_ net61 _0017_ _0150_ VSS VSS VDD VDD _0001_ sky130_fd_sc_hd__mux2i_1
XTAP_TAPCELL_ROW_8_36 VSS VDD sky130_fd_sc_hd__tapvpwrvgnd_1
X_0659_ net60 VSS VSS VDD VDD _0152_ sky130_fd_sc_hd__inv_1
XTAP_TAPCELL_ROW_7_35 VSS VDD sky130_fd_sc_hd__tapvpwrvgnd_1
XTAP_TAPCELL_ROW_7_34 VSS VDD sky130_fd_sc_hd__tapvpwrvgnd_1
XTAP_TAPCELL_ROW_7_33 VSS VDD sky130_fd_sc_hd__tapvpwrvgnd_1
XTAP_TAPCELL_ROW_7_32 VSS VDD sky130_fd_sc_hd__tapvpwrvgnd_1
X_0664_ net63 _0148_ VSS VSS VDD VDD _0156_ sky130_fd_sc_hd__and2_1
XTAP_TAPCELL_ROW_6_31 VSS VDD sky130_fd_sc_hd__tapvpwrvgnd_1
X_0666_ _0016_ _0156_ VSS VSS VDD VDD _0158_ sky130_fd_sc_hd__nor2_1
X_0667_ net60 _0158_ VSS VSS VDD VDD _0027_ sky130_fd_sc_hd__xnor2_1
XTAP_TAPCELL_ROW_6_30 VSS VDD sky130_fd_sc_hd__tapvpwrvgnd_1
X_0669_ net14 VSS VSS VDD VDD _0030_ sky130_fd_sc_hd__inv_1
XTAP_TAPCELL_ROW_6_29 VSS VDD sky130_fd_sc_hd__tapvpwrvgnd_1
X_0671_ net62 VSS VSS VDD VDD _0005_ sky130_fd_sc_hd__inv_2
XTAP_TAPCELL_ROW_6_28 VSS VDD sky130_fd_sc_hd__tapvpwrvgnd_1
XTAP_TAPCELL_ROW_5_27 VSS VDD sky130_fd_sc_hd__tapvpwrvgnd_1
XTAP_TAPCELL_ROW_5_26 VSS VDD sky130_fd_sc_hd__tapvpwrvgnd_1
X_0675_ net62 net61 net60 VSS VSS VDD VDD _0164_ sky130_fd_sc_hd__nor3_1
X_0676_ _0156_ _0164_ VSS VSS VDD VDD _0165_ sky130_fd_sc_hd__nor2_1
X_0677_ net59 _0165_ VSS VSS VDD VDD _0035_ sky130_fd_sc_hd__xnor2_1
X_0678_ _0008_ VSS VSS VDD VDD _0000_ sky130_fd_sc_hd__inv_1
XTAP_TAPCELL_ROW_5_25 VSS VDD sky130_fd_sc_hd__tapvpwrvgnd_1
X_0680_ net15 VSS VSS VDD VDD _0038_ sky130_fd_sc_hd__inv_1
X_0681_ net31 VSS VSS VDD VDD _0039_ sky130_fd_sc_hd__inv_1
X_0682_ net60 net59 VSS VSS VDD VDD _0167_ sky130_fd_sc_hd__nor2_1
X_0683_ _0016_ _0167_ _0156_ VSS VSS VDD VDD _0168_ sky130_fd_sc_hd__a21oi_1
X_0684_ net31 _0168_ VSS VSS VDD VDD _0043_ sky130_fd_sc_hd__xnor2_1
XTAP_TAPCELL_ROW_5_24 VSS VDD sky130_fd_sc_hd__tapvpwrvgnd_1
X_0686_ net16 VSS VSS VDD VDD _0046_ sky130_fd_sc_hd__inv_1
X_0687_ net32 VSS VSS VDD VDD _0047_ sky130_fd_sc_hd__inv_1
XTAP_TAPCELL_ROW_4_23 VSS VDD sky130_fd_sc_hd__tapvpwrvgnd_1
XTAP_TAPCELL_ROW_4_22 VSS VDD sky130_fd_sc_hd__tapvpwrvgnd_1
XTAP_TAPCELL_ROW_4_21 VSS VDD sky130_fd_sc_hd__tapvpwrvgnd_1
X_0691_ net62 net61 VSS VSS VDD VDD _0173_ sky130_fd_sc_hd__nor2_1
XTAP_TAPCELL_ROW_4_20 VSS VDD sky130_fd_sc_hd__tapvpwrvgnd_1
X_0693_ net60 net59 VSS VSS VDD VDD _0175_ sky130_fd_sc_hd__or2_2
X_0694_ net31 _0175_ VSS VSS VDD VDD _0176_ sky130_fd_sc_hd__nor2_1
X_0695_ _0173_ _0176_ _0156_ VSS VSS VDD VDD _0177_ sky130_fd_sc_hd__a21oi_1
X_0696_ net32 _0177_ VSS VSS VDD VDD _0051_ sky130_fd_sc_hd__xnor2_1
X_0697_ net17 VSS VSS VDD VDD _0054_ sky130_fd_sc_hd__inv_1
X_0698_ net33 VSS VSS VDD VDD _0055_ sky130_fd_sc_hd__inv_1
X_0699_ _0016_ _0047_ _0176_ VSS VSS VDD VDD _0178_ sky130_fd_sc_hd__nand3_1
X_0700_ _0150_ _0178_ VSS VSS VDD VDD _0179_ sky130_fd_sc_hd__nand2_1
X_0701_ _0055_ _0179_ VSS VSS VDD VDD _0059_ sky130_fd_sc_hd__xnor2_1
XTAP_TAPCELL_ROW_3_19 VSS VDD sky130_fd_sc_hd__tapvpwrvgnd_1
X_0703_ net18 VSS VSS VDD VDD _0062_ sky130_fd_sc_hd__inv_1
X_0704_ net34 VSS VSS VDD VDD _0063_ sky130_fd_sc_hd__inv_1
X_0705_ net62 net61 VSS VSS VDD VDD _0181_ sky130_fd_sc_hd__or2_2
X_0706_ net60 net59 net31 net32 VSS VSS VDD VDD _0182_ sky130_fd_sc_hd__or4_1
X_0707_ net33 _0181_ _0182_ VSS VSS VDD VDD _0183_ sky130_fd_sc_hd__nor3_1
X_0708_ _0156_ _0183_ VSS VSS VDD VDD _0184_ sky130_fd_sc_hd__nor2_1
X_0709_ net34 _0184_ VSS VSS VDD VDD _0067_ sky130_fd_sc_hd__xnor2_1
XTAP_TAPCELL_ROW_3_18 VSS VDD sky130_fd_sc_hd__tapvpwrvgnd_1
X_0711_ net19 VSS VSS VDD VDD _0070_ sky130_fd_sc_hd__inv_1
X_0712_ net35 VSS VSS VDD VDD _0071_ sky130_fd_sc_hd__inv_1
X_0713_ net33 _0178_ VSS VSS VDD VDD _0186_ sky130_fd_sc_hd__nor2_1
X_0714_ _0063_ _0186_ _0156_ VSS VSS VDD VDD _0187_ sky130_fd_sc_hd__a21oi_1
X_0715_ net35 _0187_ VSS VSS VDD VDD _0080_ sky130_fd_sc_hd__xnor2_1
XTAP_TAPCELL_ROW_3_17 VSS VDD sky130_fd_sc_hd__tapvpwrvgnd_1
X_0717_ net20 VSS VSS VDD VDD _0075_ sky130_fd_sc_hd__inv_1
X_0718_ net36 VSS VSS VDD VDD _0076_ sky130_fd_sc_hd__inv_1
X_0719_ net34 net35 VSS VSS VDD VDD _0189_ sky130_fd_sc_hd__nor2_1
X_0720_ _0183_ _0189_ _0156_ VSS VSS VDD VDD _0190_ sky130_fd_sc_hd__a21oi_1
X_0721_ net36 _0190_ VSS VSS VDD VDD _0088_ sky130_fd_sc_hd__xnor2_1
XTAP_TAPCELL_ROW_3_16 VSS VDD sky130_fd_sc_hd__tapvpwrvgnd_1
X_0723_ net6 VSS VSS VDD VDD _0083_ sky130_fd_sc_hd__inv_1
X_0724_ net22 VSS VSS VDD VDD _0084_ sky130_fd_sc_hd__inv_1
X_0725_ _0076_ _0186_ _0189_ _0156_ VSS VSS VDD VDD _0192_
+ sky130_fd_sc_hd__a31oi_1
X_0726_ net22 _0192_ VSS VSS VDD VDD _0096_ sky130_fd_sc_hd__xnor2_1
XTAP_TAPCELL_ROW_2_15 VSS VDD sky130_fd_sc_hd__tapvpwrvgnd_1
X_0728_ net7 VSS VSS VDD VDD _0091_ sky130_fd_sc_hd__inv_1
X_0729_ net23 VSS VSS VDD VDD _0092_ sky130_fd_sc_hd__inv_1
X_0730_ net34 net35 net36 net22 VSS VSS VDD VDD _0194_ sky130_fd_sc_hd__nor4_1
X_0731_ _0183_ _0194_ _0156_ VSS VSS VDD VDD _0195_ sky130_fd_sc_hd__a21oi_1
X_0732_ net23 _0195_ VSS VSS VDD VDD _0104_ sky130_fd_sc_hd__xnor2_1
XTAP_TAPCELL_ROW_2_14 VSS VDD sky130_fd_sc_hd__tapvpwrvgnd_1
X_0734_ net8 VSS VSS VDD VDD _0099_ sky130_fd_sc_hd__inv_1
X_0735_ net24 VSS VSS VDD VDD _0100_ sky130_fd_sc_hd__inv_1
X_0736_ _0092_ _0186_ _0194_ _0156_ VSS VSS VDD VDD _0197_
+ sky130_fd_sc_hd__a31oi_1
X_0737_ net24 _0197_ VSS VSS VDD VDD _0115_ sky130_fd_sc_hd__xnor2_1
XTAP_TAPCELL_ROW_2_13 VSS VDD sky130_fd_sc_hd__tapvpwrvgnd_1
X_0739_ net9 VSS VSS VDD VDD _0107_ sky130_fd_sc_hd__inv_1
X_0740_ net25 VSS VSS VDD VDD _0108_ sky130_fd_sc_hd__inv_1
X_0741_ _0092_ _0100_ _0194_ VSS VSS VDD VDD _0199_ sky130_fd_sc_hd__and3_1
X_0742_ _0183_ _0199_ _0156_ VSS VSS VDD VDD _0200_ sky130_fd_sc_hd__a21oi_1
X_0743_ net25 _0200_ VSS VSS VDD VDD _0112_ sky130_fd_sc_hd__xnor2_1
X_0744_ net26 VSS VSS VDD VDD _0119_ sky130_fd_sc_hd__inv_1
X_0745_ _0108_ _0186_ _0199_ _0156_ VSS VSS VDD VDD _0201_
+ sky130_fd_sc_hd__a31oi_1
X_0746_ net26 _0201_ VSS VSS VDD VDD _0123_ sky130_fd_sc_hd__xnor2_1
X_0747_ net27 VSS VSS VDD VDD _0127_ sky130_fd_sc_hd__inv_1
X_0748_ net4 net3 net2 VSS VSS VDD VDD _0202_ sky130_fd_sc_hd__and3b_1
XTAP_TAPCELL_ROW_2_12 VSS VDD sky130_fd_sc_hd__tapvpwrvgnd_1
XTAP_TAPCELL_ROW_1_11 VSS VDD sky130_fd_sc_hd__tapvpwrvgnd_1
X_0751_ net16 net17 net18 net19 net62 net61 VSS VSS VDD VDD
+ _0205_ sky130_fd_sc_hd__mux4_2
XTAP_TAPCELL_ROW_1_10 VSS VDD sky130_fd_sc_hd__tapvpwrvgnd_1
X_0753_ net12 net5 net62 VSS VSS VDD VDD _0207_ sky130_fd_sc_hd__mux2_2
X_0754_ net2 net4 net3 net63 VSS VSS VDD VDD _0208_ sky130_fd_sc_hd__nor4bb_1
XTAP_TAPCELL_ROW_1_9 VSS VDD sky130_fd_sc_hd__tapvpwrvgnd_1
XTAP_TAPCELL_ROW_1_8 VSS VDD sky130_fd_sc_hd__tapvpwrvgnd_1
X_0757_ net12 net13 net14 net15 net62 net61 VSS VSS VDD VDD
+ _0211_ sky130_fd_sc_hd__mux4_2
X_0758_ _0012_ _0207_ net58 _0202_ _0211_ VSS VSS VDD VDD
+ _0212_ sky130_fd_sc_hd__a32oi_1
X_0759_ net60 _0212_ VSS VSS VDD VDD _0213_ sky130_fd_sc_hd__nor2_1
X_0760_ net60 _0202_ _0205_ _0213_ net59 VSS VSS VDD VDD _0214_
+ sky130_fd_sc_hd__a311oi_1
X_0761_ net4 net3 net63 net2 VSS VSS VDD VDD _0215_ sky130_fd_sc_hd__and4b_1
XTAP_TAPCELL_ROW_0_7 VSS VDD sky130_fd_sc_hd__tapvpwrvgnd_1
X_0763_ net20 net7 net61 VSS VSS VDD VDD _0217_ sky130_fd_sc_hd__mux2_2
X_0764_ net62 net60 VSS VSS VDD VDD _0218_ sky130_fd_sc_hd__nor2_1
X_0765_ net60 net62 VSS VSS VDD VDD _0219_ sky130_fd_sc_hd__nor2b_1
X_0766_ net6 net8 net61 VSS VSS VDD VDD _0220_ sky130_fd_sc_hd__mux2_2
X_0767_ _0217_ _0218_ _0219_ _0220_ VSS VSS VDD VDD _0221_
+ sky130_fd_sc_hd__a22oi_1
XTAP_TAPCELL_ROW_0_6 VSS VDD sky130_fd_sc_hd__tapvpwrvgnd_1
X_0769_ net9 net10 net62 VSS VSS VDD VDD _0223_ sky130_fd_sc_hd__mux2_2
XTAP_TAPCELL_ROW_0_5 VSS VDD sky130_fd_sc_hd__tapvpwrvgnd_1
X_0771_ net11 net61 VSS VSS VDD VDD _0225_ sky130_fd_sc_hd__nand2b_1
X_0772_ net61 _0223_ _0225_ net60 VSS VSS VDD VDD _0226_ sky130_fd_sc_hd__o211ai_1
X_0773_ _0221_ _0226_ VSS VSS VDD VDD _0227_ sky130_fd_sc_hd__nand2_1
X_0774_ net6 net10 net60 VSS VSS VDD VDD _0228_ sky130_fd_sc_hd__mux2_2
X_0775_ net60 net61 VSS VSS VDD VDD _0229_ sky130_fd_sc_hd__nor2b_1
X_0776_ _0012_ _0228_ _0229_ net8 VSS VSS VDD VDD _0230_ sky130_fd_sc_hd__a22oi_1
X_0777_ net20 net7 net9 net11 net61 net60 VSS VSS VDD VDD
+ _0231_ sky130_fd_sc_hd__mux4_2
X_0778_ net63 net4 net3 net2 VSS VSS VDD VDD _0232_ sky130_fd_sc_hd__nor4bb_1
X_0779_ net62 _0231_ _0232_ VSS VSS VDD VDD _0233_ sky130_fd_sc_hd__o21ai_0
X_0780_ net62 _0230_ _0233_ VSS VSS VDD VDD _0234_ sky130_fd_sc_hd__a21oi_1
X_0781_ _0215_ _0227_ _0132_ _0234_ VSS VSS VDD VDD _0235_
+ sky130_fd_sc_hd__a211oi_1
X_0782_ net63 net3 net4 net2 VSS VSS VDD VDD _0236_ sky130_fd_sc_hd__nor4b_1
X_0783_ net3 net4 net2 net63 VSS VSS VDD VDD _0237_ sky130_fd_sc_hd__nand4bb_1
XTAP_TAPCELL_ROW_0_4 VSS VDD sky130_fd_sc_hd__tapvpwrvgnd_1
X_0785_ _0003_ _0148_ VSS VSS VDD VDD _0239_ sky130_fd_sc_hd__nand2_1
X_0786_ _0013_ _0237_ _0239_ VSS VSS VDD VDD _0240_ sky130_fd_sc_hd__o21ai_0
X_0787_ net2 net63 net3 net4 VSS VSS VDD VDD _0241_ sky130_fd_sc_hd__or4b_2
XTAP_TAPCELL_ROW_0_3 VSS VDD sky130_fd_sc_hd__tapvpwrvgnd_1
X_0789_ net2 net63 net4 net3 VSS VSS VDD VDD _0243_ sky130_fd_sc_hd__nor4b_1
X_0790_ _0015_ _0243_ VSS VSS VDD VDD _0244_ sky130_fd_sc_hd__nand2_1
X_0791_ net12 _0241_ _0244_ VSS VSS VDD VDD _0245_ sky130_fd_sc_hd__o21ai_0
X_0792_ _0014_ _0236_ _0240_ _0245_ VSS VSS VDD VDD _0246_
+ sky130_fd_sc_hd__a211oi_1
X_0793_ _0214_ _0235_ _0246_ VSS VSS VDD VDD net44 sky130_fd_sc_hd__o21ai_0
X_0794_ net19 net6 net8 net10 net61 net60 VSS VSS VDD VDD
+ _0247_ sky130_fd_sc_hd__mux4_2
X_0795_ _0231_ _0247_ _0005_ VSS VSS VDD VDD _0248_ sky130_fd_sc_hd__mux2_4
X_0796_ net4 net3 VSS VSS VDD VDD _0249_ sky130_fd_sc_hd__nor2b_1
X_0797_ net2 _0249_ VSS VSS VDD VDD _0250_ sky130_fd_sc_hd__nand2_1
X_0798_ net5 net12 net13 net14 net62 net61 VSS VSS VDD VDD
+ _0251_ sky130_fd_sc_hd__mux4_2
X_0799_ net60 _0251_ VSS VSS VDD VDD _0252_ sky130_fd_sc_hd__nor2_1
X_0800_ net15 net16 net17 net18 net62 net61 VSS VSS VDD VDD
+ _0253_ sky130_fd_sc_hd__mux4_2
X_0801_ _0152_ _0253_ VSS VSS VDD VDD _0254_ sky130_fd_sc_hd__nor2_1
X_0802_ net59 _0250_ _0252_ _0254_ VSS VSS VDD VDD _0255_
+ sky130_fd_sc_hd__nor4_1
X_0803_ net61 net60 net59 VSS VSS VDD VDD _0256_ sky130_fd_sc_hd__nor3_1
X_0804_ _0009_ net58 _0256_ VSS VSS VDD VDD _0257_ sky130_fd_sc_hd__nand3_1
X_0805_ net2 net63 net3 net4 VSS VSS VDD VDD _0258_ sky130_fd_sc_hd__nor4b_1
X_0806_ net5 _0258_ _0243_ _0010_ VSS VSS VDD VDD _0259_ sky130_fd_sc_hd__a22oi_1
X_0807_ _0006_ net63 net2 VSS VSS VDD VDD _0260_ sky130_fd_sc_hd__and3b_1
X_0808_ net2 net63 _0007_ VSS VSS VDD VDD _0261_ sky130_fd_sc_hd__a21boi_0
X_0809_ net3 net4 VSS VSS VDD VDD _0262_ sky130_fd_sc_hd__nor2_1
X_0810_ _0260_ _0261_ _0262_ VSS VSS VDD VDD _0263_ sky130_fd_sc_hd__o21ai_0
X_0811_ _0257_ _0259_ _0263_ VSS VSS VDD VDD _0264_ sky130_fd_sc_hd__nand3_1
X_0812_ net59 _0202_ _0248_ _0255_ _0264_ VSS VSS VDD VDD
+ net37 sky130_fd_sc_hd__a311o_1
X_0813_ net14 net13 net12 net5 net62 net61 VSS VSS VDD VDD
+ _0265_ sky130_fd_sc_hd__mux4_2
X_0814_ net14 net15 net16 net17 net62 net61 VSS VSS VDD VDD
+ _0266_ sky130_fd_sc_hd__mux4_2
X_0815_ net58 _0265_ _0266_ _0202_ VSS VSS VDD VDD _0267_
+ sky130_fd_sc_hd__a22oi_1
X_0816_ _0175_ _0267_ VSS VSS VDD VDD _0268_ sky130_fd_sc_hd__nor2_1
X_0817_ _0008_ _0019_ VSS VSS VDD VDD _0269_ sky130_fd_sc_hd__nor2b_1
X_0818_ _0018_ _0269_ _0029_ VSS VSS VDD VDD _0270_ sky130_fd_sc_hd__o21ai_0
X_0819_ _0037_ _0028_ VSS VSS VDD VDD _0271_ sky130_fd_sc_hd__nor2_1
X_0820_ _0029_ _0028_ _0037_ VSS VSS VDD VDD _0272_ sky130_fd_sc_hd__o21a_1
X_0821_ _0018_ _0028_ _0269_ _0272_ VSS VSS VDD VDD _0273_
+ sky130_fd_sc_hd__o31a_1
X_0822_ net2 net3 net4 VSS VSS VDD VDD _0274_ sky130_fd_sc_hd__or3_1
XTAP_TAPCELL_ROW_0_2 VSS VDD sky130_fd_sc_hd__tapvpwrvgnd_1
X_0824_ _0270_ _0271_ _0273_ _0274_ VSS VSS VDD VDD _0276_
+ sky130_fd_sc_hd__a211oi_1
X_0825_ net18 net19 net20 net6 net62 net61 VSS VSS VDD VDD
+ _0277_ sky130_fd_sc_hd__mux4_2
X_0826_ net59 net60 VSS VSS VDD VDD _0278_ sky130_fd_sc_hd__nor2b_1
X_0827_ _0202_ _0277_ _0278_ VSS VSS VDD VDD _0279_ sky130_fd_sc_hd__nand3_1
X_0828_ net14 _0020_ VSS VSS VDD VDD _0280_ sky130_fd_sc_hd__xor2_1
X_0829_ _0258_ _0280_ VSS VSS VDD VDD _0281_ sky130_fd_sc_hd__nand2_1
X_0830_ _0034_ _0243_ _0236_ _0033_ VSS VSS VDD VDD _0282_
+ sky130_fd_sc_hd__a22oi_1
X_0831_ _0032_ _0237_ _0279_ _0281_ _0282_ VSS VSS VDD VDD
+ _0283_ sky130_fd_sc_hd__o2111ai_1
X_0832_ net7 net8 net9 net10 net62 net61 VSS VSS VDD VDD _0284_
+ sky130_fd_sc_hd__mux4_2
X_0833_ _0152_ _0284_ VSS VSS VDD VDD _0285_ sky130_fd_sc_hd__and2_1
X_0834_ net4 net3 net63 net2 VSS VSS VDD VDD _0286_ sky130_fd_sc_hd__nand4b_1
XTAP_TAPCELL_ROW_0_1 VSS VDD sky130_fd_sc_hd__tapvpwrvgnd_1
X_0836_ net60 net11 VSS VSS VDD VDD _0288_ sky130_fd_sc_hd__nand2_1
X_0837_ _0181_ _0286_ _0288_ VSS VSS VDD VDD _0289_ sky130_fd_sc_hd__a21oi_1
X_0838_ _0285_ _0289_ net59 _0202_ VSS VSS VDD VDD _0290_
+ sky130_fd_sc_hd__o211ai_1
X_0839_ _0268_ _0276_ _0283_ _0290_ VSS VSS VDD VDD _0291_
+ sky130_fd_sc_hd__nor4b_1
X_0840_ _0291_ VSS VSS VDD VDD net46 sky130_fd_sc_hd__inv_1
X_0841_ net3 _0024_ VSS VSS VDD VDD _0292_ sky130_fd_sc_hd__nor2_1
X_0842_ net2 net63 _0292_ VSS VSS VDD VDD _0293_ sky130_fd_sc_hd__nand3_1
X_0843_ net2 net63 VSS VSS VDD VDD _0294_ sky130_fd_sc_hd__nor2_1
X_0844_ net3 _0026_ _0294_ VSS VSS VDD VDD _0295_ sky130_fd_sc_hd__nand3_1
X_0845_ _0293_ _0295_ net4 VSS VSS VDD VDD _0296_ sky130_fd_sc_hd__a21oi_1
X_0846_ _0002_ _0029_ VSS VSS VDD VDD _0297_ sky130_fd_sc_hd__xnor2_1
X_0847_ _0021_ _0258_ _0236_ _0025_ VSS VSS VDD VDD _0298_
+ sky130_fd_sc_hd__a22oi_1
X_0848_ _0274_ _0297_ _0298_ VSS VSS VDD VDD _0299_ sky130_fd_sc_hd__o21ai_0
X_0849_ _0296_ _0299_ VSS VSS VDD VDD _0300_ sky130_fd_sc_hd__nor2_1
X_0850_ net60 net10 VSS VSS VDD VDD _0301_ sky130_fd_sc_hd__nand2_1
X_0851_ _0301_ _0288_ _0181_ VSS VSS VDD VDD _0302_ sky130_fd_sc_hd__mux2_2
X_0852_ net10 net11 net62 VSS VSS VDD VDD _0303_ sky130_fd_sc_hd__mux2i_1
X_0853_ net61 net60 VSS VSS VDD VDD _0304_ sky130_fd_sc_hd__nor2b_1
X_0854_ _0303_ _0304_ net59 _0232_ VSS VSS VDD VDD _0305_
+ sky130_fd_sc_hd__nand4b_1
X_0855_ _0132_ _0286_ _0302_ _0305_ VSS VSS VDD VDD _0306_
+ sky130_fd_sc_hd__o31ai_1
X_0856_ net7 net9 net61 VSS VSS VDD VDD _0307_ sky130_fd_sc_hd__mux2_2
X_0857_ _0219_ _0307_ VSS VSS VDD VDD _0308_ sky130_fd_sc_hd__nand2_1
X_0858_ _0220_ _0218_ VSS VSS VDD VDD _0309_ sky130_fd_sc_hd__nand2_1
X_0859_ net59 _0308_ _0309_ _0250_ VSS VSS VDD VDD _0310_
+ sky130_fd_sc_hd__a31oi_1
X_0860_ net13 net12 net62 VSS VSS VDD VDD _0311_ sky130_fd_sc_hd__mux2_2
X_0861_ _0009_ net61 VSS VSS VDD VDD _0312_ sky130_fd_sc_hd__or2b_1
X_0862_ net61 _0311_ _0312_ net58 VSS VSS VDD VDD _0313_ sky130_fd_sc_hd__o211ai_1
X_0863_ _0175_ _0313_ VSS VSS VDD VDD _0314_ sky130_fd_sc_hd__nor2_1
X_0864_ net13 net14 net15 net16 net62 net61 VSS VSS VDD VDD
+ _0315_ sky130_fd_sc_hd__mux4_2
X_0865_ _0315_ VSS VSS VDD VDD _0316_ sky130_fd_sc_hd__inv_1
X_0866_ net17 net18 net19 net20 net62 net61 VSS VSS VDD VDD
+ _0317_ sky130_fd_sc_hd__mux4_2
X_0867_ _0152_ net59 _0317_ VSS VSS VDD VDD _0318_ sky130_fd_sc_hd__nor3_1
X_0868_ _0167_ _0313_ _0316_ _0318_ VSS VSS VDD VDD _0319_
+ sky130_fd_sc_hd__a31oi_1
X_0869_ _0306_ _0310_ _0314_ _0319_ VSS VSS VDD VDD _0320_
+ sky130_fd_sc_hd__o31ai_1
X_0870_ _0300_ _0320_ VSS VSS VDD VDD net45 sky130_fd_sc_hd__nand2_1
X_0871_ _0045_ _0044_ _0053_ VSS VSS VDD VDD _0321_ sky130_fd_sc_hd__o21a_1
X_0872_ _0036_ _0044_ _0273_ _0321_ VSS VSS VDD VDD _0322_
+ sky130_fd_sc_hd__o31ai_1
X_0873_ _0037_ _0028_ _0036_ VSS VSS VDD VDD _0323_ sky130_fd_sc_hd__a21o_1
X_0874_ _0045_ _0323_ VSS VSS VDD VDD _0324_ sky130_fd_sc_hd__nand2_1
X_0875_ _0018_ _0269_ _0029_ _0037_ _0045_ VSS VSS VDD VDD
+ _0325_ sky130_fd_sc_hd__o2111ai_1
X_0876_ _0053_ _0044_ VSS VSS VDD VDD _0326_ sky130_fd_sc_hd__nor2_1
X_0877_ _0324_ _0325_ _0326_ _0274_ VSS VSS VDD VDD _0327_
+ sky130_fd_sc_hd__a31oi_1
X_0878_ _0322_ _0327_ VSS VSS VDD VDD _0328_ sky130_fd_sc_hd__nand2_1
X_0879_ net2 net63 _0249_ VSS VSS VDD VDD _0329_ sky130_fd_sc_hd__nand3b_1
X_0880_ net16 net15 net14 net13 net62 net61 VSS VSS VDD VDD
+ _0330_ sky130_fd_sc_hd__mux4_2
X_0881_ net60 _0330_ VSS VSS VDD VDD _0331_ sky130_fd_sc_hd__nor2_1
X_0882_ _0012_ _0207_ _0152_ VSS VSS VDD VDD _0332_ sky130_fd_sc_hd__a21oi_1
X_0883_ net16 net18 net20 net7 net61 net60 VSS VSS VDD VDD
+ _0333_ sky130_fd_sc_hd__mux4_2
X_0884_ net62 net59 VSS VSS VDD VDD _0334_ sky130_fd_sc_hd__or2_2
X_0885_ net59 net62 VSS VSS VDD VDD _0335_ sky130_fd_sc_hd__nand2b_1
X_0886_ net17 net19 net6 net8 net61 net60 VSS VSS VDD VDD
+ _0336_ sky130_fd_sc_hd__mux4_1
X_0887_ _0333_ _0334_ _0335_ _0336_ VSS VSS VDD VDD _0337_
+ sky130_fd_sc_hd__o22ai_1
X_0888_ _0329_ _0331_ _0332_ _0250_ _0337_ VSS VSS VDD VDD
+ _0338_ sky130_fd_sc_hd__o32ai_1
X_0889_ _0152_ _0232_ VSS VSS VDD VDD _0339_ sky130_fd_sc_hd__nand2_1
X_0890_ net61 net9 VSS VSS VDD VDD _0340_ sky130_fd_sc_hd__or2_2
X_0891_ net61 net62 VSS VSS VDD VDD _0341_ sky130_fd_sc_hd__nor2b_1
X_0892_ _0005_ _0225_ _0340_ _0341_ net10 VSS VSS VDD VDD
+ _0342_ sky130_fd_sc_hd__a32oi_1
XTAP_TAPCELL_ROW_0_0 VSS VDD sky130_fd_sc_hd__tapvpwrvgnd_1
X_0894_ net61 net60 VSS VSS VDD VDD _0344_ sky130_fd_sc_hd__nor2_1
X_0895_ net11 _0223_ _0344_ VSS VSS VDD VDD _0345_ sky130_fd_sc_hd__mux2i_1
X_0896_ _0339_ _0342_ _0345_ _0286_ net59 VSS VSS VDD VDD
+ _0346_ sky130_fd_sc_hd__o221ai_1
X_0897_ net14 net15 _0020_ VSS VSS VDD VDD _0347_ sky130_fd_sc_hd__nand3_1
X_0898_ _0046_ _0347_ VSS VSS VDD VDD _0348_ sky130_fd_sc_hd__xnor2_1
X_0899_ net2 net3 _0050_ VSS VSS VDD VDD _0349_ sky130_fd_sc_hd__nand3b_1
X_0900_ net3 _0049_ net2 VSS VSS VDD VDD _0350_ sky130_fd_sc_hd__nand3b_1
X_0901_ _0349_ _0350_ net63 net4 VSS VSS VDD VDD _0351_ sky130_fd_sc_hd__a211o_1
X_0902_ _0048_ _0237_ _0348_ _0241_ _0351_ VSS VSS VDD VDD
+ _0352_ sky130_fd_sc_hd__o221ai_1
X_0903_ _0338_ _0346_ _0352_ VSS VSS VDD VDD _0353_ sky130_fd_sc_hd__a21oi_1
X_0904_ _0328_ _0353_ VSS VSS VDD VDD net48 sky130_fd_sc_hd__nand2_1
X_0905_ _0040_ _0237_ VSS VSS VDD VDD _0354_ sky130_fd_sc_hd__nor2_1
X_0906_ net2 net3 VSS VSS VDD VDD _0355_ sky130_fd_sc_hd__nor2b_1
X_0907_ net3 net2 VSS VSS VDD VDD _0356_ sky130_fd_sc_hd__nor2b_1
X_0908_ _0042_ _0355_ _0356_ _0041_ VSS VSS VDD VDD _0357_
+ sky130_fd_sc_hd__a22oi_1
X_0909_ net12 net13 net14 VSS VSS VDD VDD _0358_ sky130_fd_sc_hd__nand3_1
X_0910_ _0038_ _0358_ VSS VSS VDD VDD _0359_ sky130_fd_sc_hd__xnor2_1
X_0911_ net63 net4 _0357_ _0359_ _0241_ VSS VSS VDD VDD _0360_
+ sky130_fd_sc_hd__o32ai_1
X_0912_ _0002_ _0029_ _0028_ VSS VSS VDD VDD _0361_ sky130_fd_sc_hd__a21o_1
X_0913_ _0037_ _0361_ _0036_ _0045_ VSS VSS VDD VDD _0362_
+ sky130_fd_sc_hd__a211oi_1
X_0914_ _0002_ _0029_ _0028_ _0036_ VSS VSS VDD VDD _0363_
+ sky130_fd_sc_hd__a211oi_1
X_0915_ _0037_ _0036_ _0045_ VSS VSS VDD VDD _0364_ sky130_fd_sc_hd__o21ai_0
X_0916_ _0363_ _0364_ _0148_ VSS VSS VDD VDD _0365_ sky130_fd_sc_hd__o21ai_0
X_0917_ _0362_ _0365_ VSS VSS VDD VDD _0366_ sky130_fd_sc_hd__nor2_1
X_0918_ _0354_ _0360_ _0366_ VSS VSS VDD VDD _0367_ sky130_fd_sc_hd__nor3_1
X_0919_ net14 _0009_ net60 VSS VSS VDD VDD _0368_ sky130_fd_sc_hd__mux2_2
X_0920_ _0341_ _0368_ VSS VSS VDD VDD _0369_ sky130_fd_sc_hd__nand2_1
X_0921_ net12 net62 _0229_ VSS VSS VDD VDD _0370_ sky130_fd_sc_hd__nand3_1
X_0922_ net15 net13 net61 VSS VSS VDD VDD _0371_ sky130_fd_sc_hd__mux2_2
X_0923_ _0009_ _0304_ _0371_ _0218_ VSS VSS VDD VDD _0372_
+ sky130_fd_sc_hd__a22oi_1
X_0924_ _0369_ _0370_ _0372_ _0329_ VSS VSS VDD VDD _0373_
+ sky130_fd_sc_hd__a31oi_1
X_0925_ net15 net17 net19 net6 net61 net60 VSS VSS VDD VDD
+ _0374_ sky130_fd_sc_hd__mux4_2
X_0926_ _0333_ _0374_ _0005_ VSS VSS VDD VDD _0375_ sky130_fd_sc_hd__mux2i_1
X_0927_ _0132_ _0375_ _0250_ VSS VSS VDD VDD _0376_ sky130_fd_sc_hd__a21oi_1
X_0928_ net8 net9 net10 net11 net62 net61 VSS VSS VDD VDD
+ _0377_ sky130_fd_sc_hd__mux4_2
X_0929_ _0202_ _0377_ VSS VSS VDD VDD _0378_ sky130_fd_sc_hd__nand2_1
X_0930_ _0288_ _0286_ _0378_ net60 net59 VSS VSS VDD VDD _0379_
+ sky130_fd_sc_hd__o221ai_1
X_0931_ _0373_ _0376_ _0379_ VSS VSS VDD VDD _0380_ sky130_fd_sc_hd__o21ai_0
X_0932_ _0367_ _0380_ VSS VSS VDD VDD net47 sky130_fd_sc_hd__nand2_1
X_0933_ _0053_ _0052_ VSS VSS VDD VDD _0381_ sky130_fd_sc_hd__or2_2
X_0934_ _0061_ _0381_ _0060_ VSS VSS VDD VDD _0382_ sky130_fd_sc_hd__a21oi_1
X_0935_ _0044_ _0052_ _0060_ VSS VSS VDD VDD _0383_ sky130_fd_sc_hd__nor3_1
X_0936_ _0324_ _0325_ _0383_ VSS VSS VDD VDD _0384_ sky130_fd_sc_hd__and3_1
X_0937_ _0382_ _0384_ VSS VSS VDD VDD _0385_ sky130_fd_sc_hd__nor2_1
X_0938_ _0069_ _0385_ VSS VSS VDD VDD _0386_ sky130_fd_sc_hd__xnor2_1
X_0939_ _0064_ _0237_ VSS VSS VDD VDD _0387_ sky130_fd_sc_hd__nor2_1
X_0940_ net11 VSS VSS VDD VDD _0126_ sky130_fd_sc_hd__inv_1
X_0941_ _0126_ _0132_ _0181_ _0339_ VSS VSS VDD VDD _0388_
+ sky130_fd_sc_hd__nor4_1
X_0942_ _0066_ _0355_ _0356_ _0065_ VSS VSS VDD VDD _0389_
+ sky130_fd_sc_hd__a22oi_1
X_0943_ net63 net4 _0389_ VSS VSS VDD VDD _0390_ sky130_fd_sc_hd__nor3_1
X_0944_ _0126_ _0132_ _0286_ VSS VSS VDD VDD _0391_ sky130_fd_sc_hd__nor3_1
X_0945_ _0387_ _0388_ _0390_ _0391_ VSS VSS VDD VDD _0392_
+ sky130_fd_sc_hd__nor4_1
X_0946_ net14 net15 net16 _0020_ VSS VSS VDD VDD _0393_ sky130_fd_sc_hd__and4_1
X_0947_ net17 _0393_ VSS VSS VDD VDD _0394_ sky130_fd_sc_hd__nand2_1
X_0948_ net18 _0394_ VSS VSS VDD VDD _0395_ sky130_fd_sc_hd__xnor2_1
X_0949_ net55 _0395_ VSS VSS VDD VDD _0396_ sky130_fd_sc_hd__nand2_1
X_0950_ _0152_ _0265_ VSS VSS VDD VDD _0397_ sky130_fd_sc_hd__nor2_1
X_0951_ net18 net17 net16 net15 net62 net61 VSS VSS VDD VDD
+ _0398_ sky130_fd_sc_hd__mux4_2
X_0952_ net60 _0398_ VSS VSS VDD VDD _0399_ sky130_fd_sc_hd__nor2_1
X_0953_ _0329_ _0397_ _0399_ VSS VSS VDD VDD _0400_ sky130_fd_sc_hd__nor3_1
X_0954_ net18 net20 net7 net9 net61 net60 VSS VSS VDD VDD
+ _0401_ sky130_fd_sc_hd__mux4_1
X_0955_ _0401_ _0005_ VSS VSS VDD VDD _0402_ sky130_fd_sc_hd__nand2b_1
X_0956_ _0005_ _0247_ _0402_ _0202_ VSS VSS VDD VDD _0403_
+ sky130_fd_sc_hd__o211a_1
X_0957_ _0400_ _0403_ _0132_ VSS VSS VDD VDD _0404_ sky130_fd_sc_hd__o21ai_0
X_0958_ _0274_ _0386_ _0392_ _0396_ _0404_ VSS VSS VDD VDD
+ net50 sky130_fd_sc_hd__o2111ai_1
X_0959_ net61 _0311_ _0312_ net60 VSS VSS VDD VDD _0405_ sky130_fd_sc_hd__o211ai_1
X_0960_ net17 net16 net15 net14 net62 net61 VSS VSS VDD VDD
+ _0406_ sky130_fd_sc_hd__mux4_2
X_0961_ _0152_ _0406_ VSS VSS VDD VDD _0407_ sky130_fd_sc_hd__nand2_1
X_0962_ _0405_ _0407_ _0329_ VSS VSS VDD VDD _0408_ sky130_fd_sc_hd__a21oi_1
X_0963_ _0336_ _0401_ net62 VSS VSS VDD VDD _0409_ sky130_fd_sc_hd__mux2i_1
X_0964_ _0132_ _0409_ _0250_ VSS VSS VDD VDD _0410_ sky130_fd_sc_hd__a21oi_1
X_0965_ net11 net10 _0164_ VSS VSS VDD VDD _0411_ sky130_fd_sc_hd__mux2i_1
X_0966_ net61 _0303_ VSS VSS VDD VDD _0412_ sky130_fd_sc_hd__or2_2
X_0967_ _0286_ _0411_ _0412_ _0339_ net59 VSS VSS VDD VDD
+ _0413_ sky130_fd_sc_hd__o221ai_1
X_0968_ _0408_ _0410_ _0413_ VSS VSS VDD VDD _0414_ sky130_fd_sc_hd__o21a_1
X_0969_ _0037_ _0045_ _0053_ VSS VSS VDD VDD _0415_ sky130_fd_sc_hd__and3_1
X_0970_ _0053_ _0044_ VSS VSS VDD VDD _0416_ sky130_fd_sc_hd__and2_1
X_0971_ _0045_ _0053_ _0036_ VSS VSS VDD VDD _0417_ sky130_fd_sc_hd__and3_1
X_0972_ _0361_ _0415_ _0416_ _0417_ _0052_ VSS VSS VDD VDD
+ _0418_ sky130_fd_sc_hd__a2111oi_0
X_0973_ _0061_ _0418_ VSS VSS VDD VDD _0419_ sky130_fd_sc_hd__xor2_1
X_0974_ _0274_ _0419_ VSS VSS VDD VDD _0420_ sky130_fd_sc_hd__nor2_1
X_0975_ net12 net13 net14 net15 VSS VSS VDD VDD _0421_ sky130_fd_sc_hd__and4_1
X_0976_ net16 _0421_ VSS VSS VDD VDD _0422_ sky130_fd_sc_hd__nand2_1
X_0977_ _0054_ _0422_ VSS VSS VDD VDD _0423_ sky130_fd_sc_hd__xnor2_1
X_0978_ _0058_ _0355_ _0356_ _0057_ VSS VSS VDD VDD _0424_
+ sky130_fd_sc_hd__a22oi_1
X_0979_ net63 net4 _0424_ VSS VSS VDD VDD _0425_ sky130_fd_sc_hd__or3_1
X_0980_ _0056_ _0237_ _0423_ _0241_ _0425_ VSS VSS VDD VDD
+ _0426_ sky130_fd_sc_hd__o221a_2
X_0981_ _0414_ _0420_ _0426_ VSS VSS VDD VDD net49 sky130_fd_sc_hd__or3b_2
X_0982_ _0090_ VSS VSS VDD VDD _0427_ sky130_fd_sc_hd__inv_1
X_0983_ _0082_ _0069_ VSS VSS VDD VDD _0428_ sky130_fd_sc_hd__nand2_1
X_0984_ _0082_ _0068_ _0081_ VSS VSS VDD VDD _0429_ sky130_fd_sc_hd__a21oi_1
X_0985_ _0382_ _0384_ _0428_ _0429_ VSS VSS VDD VDD _0430_
+ sky130_fd_sc_hd__o31ai_1
X_0986_ _0427_ _0430_ VSS VSS VDD VDD _0431_ sky130_fd_sc_hd__xnor2_1
X_0987_ _0126_ net59 _0286_ VSS VSS VDD VDD _0432_ sky130_fd_sc_hd__a21oi_1
X_0988_ net59 _0227_ _0432_ VSS VSS VDD VDD _0433_ sky130_fd_sc_hd__o21ai_0
X_0989_ net17 net18 net19 _0393_ VSS VSS VDD VDD _0434_ sky130_fd_sc_hd__nand4_1
X_0990_ net20 _0434_ VSS VSS VDD VDD _0435_ sky130_fd_sc_hd__xnor2_1
X_0991_ net3 net4 net2 VSS VSS VDD VDD _0436_ sky130_fd_sc_hd__or3b_2
X_0992_ _0077_ VSS VSS VDD VDD _0437_ sky130_fd_sc_hd__inv_1
X_0993_ _0078_ _0437_ net63 VSS VSS VDD VDD _0438_ sky130_fd_sc_hd__mux2i_1
X_0994_ _0436_ _0438_ VSS VSS VDD VDD _0439_ sky130_fd_sc_hd__nor2_1
X_0995_ _0079_ net56 _0435_ net55 _0439_ VSS VSS VDD VDD _0440_
+ sky130_fd_sc_hd__a221oi_1
X_0996_ _0012_ _0207_ VSS VSS VDD VDD _0441_ sky130_fd_sc_hd__nand2_1
X_0997_ net60 _0441_ _0329_ VSS VSS VDD VDD _0442_ sky130_fd_sc_hd__nor3_1
X_0998_ net19 net17 net15 net13 net61 net60 VSS VSS VDD VDD
+ _0443_ sky130_fd_sc_hd__mux4_2
X_0999_ net20 net18 net16 net14 net61 net60 VSS VSS VDD VDD
+ _0444_ sky130_fd_sc_hd__mux4_2
X_1000_ _0335_ _0443_ _0444_ _0334_ VSS VSS VDD VDD _0445_
+ sky130_fd_sc_hd__o22ai_1
X_1001_ _0329_ _0445_ VSS VSS VDD VDD _0446_ sky130_fd_sc_hd__nor2_1
X_1002_ _0132_ _0442_ _0446_ _0234_ VSS VSS VDD VDD _0447_
+ sky130_fd_sc_hd__o22ai_1
X_1003_ _0433_ _0440_ _0447_ VSS VSS VDD VDD _0448_ sky130_fd_sc_hd__nand3_1
X_1004_ _0148_ _0431_ _0448_ VSS VSS VDD VDD net52 sky130_fd_sc_hd__a21o_1
X_1005_ _0082_ _0274_ VSS VSS VDD VDD _0449_ sky130_fd_sc_hd__nor2_1
X_1006_ _0082_ _0148_ VSS VSS VDD VDD _0450_ sky130_fd_sc_hd__and2_1
X_1007_ _0061_ _0381_ _0060_ VSS VSS VDD VDD _0451_ sky130_fd_sc_hd__a21o_1
X_1008_ _0363_ _0364_ _0383_ VSS VSS VDD VDD _0452_ sky130_fd_sc_hd__o21ai_0
X_1009_ _0069_ _0451_ _0452_ _0068_ VSS VSS VDD VDD _0453_
+ sky130_fd_sc_hd__a31oi_1
X_1010_ _0449_ _0450_ _0453_ VSS VSS VDD VDD _0454_ sky130_fd_sc_hd__mux2i_1
X_1011_ net19 net18 net17 net16 net62 net61 VSS VSS VDD VDD
+ _0455_ sky130_fd_sc_hd__mux4_2
X_1012_ net61 net59 _0009_ VSS VSS VDD VDD _0456_ sky130_fd_sc_hd__and3b_1
X_1013_ _0132_ _0455_ _0456_ VSS VSS VDD VDD _0457_ sky130_fd_sc_hd__a21oi_1
X_1014_ net15 net14 net13 net12 net62 net61 VSS VSS VDD VDD
+ _0458_ sky130_fd_sc_hd__mux4_2
X_1015_ _0278_ _0458_ VSS VSS VDD VDD _0459_ sky130_fd_sc_hd__nand2_1
X_1016_ net60 _0457_ _0459_ VSS VSS VDD VDD _0460_ sky130_fd_sc_hd__o21ai_0
X_1017_ _0132_ _0202_ _0248_ VSS VSS VDD VDD _0461_ sky130_fd_sc_hd__and3_1
X_1018_ _0072_ net63 VSS VSS VDD VDD _0462_ sky130_fd_sc_hd__nand2b_1
X_1019_ net63 _0073_ VSS VSS VDD VDD _0463_ sky130_fd_sc_hd__nand2b_1
X_1020_ _0462_ _0463_ _0436_ VSS VSS VDD VDD _0464_ sky130_fd_sc_hd__a21oi_1
X_1021_ _0074_ net56 _0391_ _0464_ VSS VSS VDD VDD _0465_
+ sky130_fd_sc_hd__a211o_1
X_1022_ net16 net17 net18 VSS VSS VDD VDD _0466_ sky130_fd_sc_hd__and3_1
X_1023_ net19 _0241_ VSS VSS VDD VDD _0467_ sky130_fd_sc_hd__nor2_1
X_1024_ _0421_ _0466_ _0070_ _0241_ VSS VSS VDD VDD _0468_
+ sky130_fd_sc_hd__a211oi_1
X_1025_ _0421_ _0466_ _0467_ _0468_ VSS VSS VDD VDD _0469_
+ sky130_fd_sc_hd__a31o_2
X_1026_ net58 _0460_ _0461_ _0465_ _0469_ VSS VSS VDD VDD
+ _0470_ sky130_fd_sc_hd__a2111oi_0
X_1027_ _0454_ _0470_ VSS VSS VDD VDD net51 sky130_fd_sc_hd__nand2_1
X_1028_ _0036_ _0044_ _0052_ _0273_ VSS VSS VDD VDD _0471_
+ sky130_fd_sc_hd__nor4_1
X_1029_ _0090_ _0098_ VSS VSS VDD VDD _0472_ sky130_fd_sc_hd__nand2_1
X_1030_ _0428_ _0472_ VSS VSS VDD VDD _0473_ sky130_fd_sc_hd__nor2_1
X_1031_ _0052_ _0321_ _0473_ _0061_ VSS VSS VDD VDD _0474_
+ sky130_fd_sc_hd__o211ai_1
X_1032_ _0427_ _0429_ _0089_ VSS VSS VDD VDD _0475_ sky130_fd_sc_hd__o21bai_1
X_1033_ _0060_ _0473_ _0475_ _0098_ _0097_ VSS VSS VDD VDD
+ _0476_ sky130_fd_sc_hd__a221oi_1
X_1034_ _0471_ _0474_ _0476_ VSS VSS VDD VDD _0477_ sky130_fd_sc_hd__o21ai_0
X_1035_ _0106_ _0477_ VSS VSS VDD VDD _0478_ sky130_fd_sc_hd__xor2_1
X_1036_ net17 net18 net19 net20 VSS VSS VDD VDD _0479_ sky130_fd_sc_hd__and4_1
X_1037_ net6 _0393_ _0479_ VSS VSS VDD VDD _0480_ sky130_fd_sc_hd__nand3_1
X_1038_ _0091_ _0480_ VSS VSS VDD VDD _0481_ sky130_fd_sc_hd__xnor2_1
X_1039_ net7 net6 net20 net19 net62 net61 VSS VSS VDD VDD
+ _0482_ sky130_fd_sc_hd__mux4_2
X_1040_ _0278_ _0398_ _0482_ _0167_ VSS VSS VDD VDD _0483_
+ sky130_fd_sc_hd__a22oi_1
X_1041_ net60 net59 VSS VSS VDD VDD _0484_ sky130_fd_sc_hd__nor2b_1
X_1042_ _0265_ _0484_ VSS VSS VDD VDD _0485_ sky130_fd_sc_hd__nand2_1
X_1043_ _0483_ _0485_ VSS VSS VDD VDD _0486_ sky130_fd_sc_hd__nand2_1
X_1044_ net58 _0486_ VSS VSS VDD VDD _0487_ sky130_fd_sc_hd__nand2_1
X_1045_ net60 net11 _0173_ _0285_ VSS VSS VDD VDD _0488_ sky130_fd_sc_hd__a31oi_1
X_1046_ net63 net59 _0250_ _0488_ VSS VSS VDD VDD _0489_ sky130_fd_sc_hd__or4_1
X_1047_ _0095_ net56 VSS VSS VDD VDD _0490_ sky130_fd_sc_hd__nand2_1
X_1048_ net11 _0175_ _0215_ net57 _0094_ VSS VSS VDD VDD _0491_
+ sky130_fd_sc_hd__a32oi_1
X_1049_ _0093_ _0237_ _0490_ _0491_ VSS VSS VDD VDD _0492_
+ sky130_fd_sc_hd__o211ai_1
X_1050_ _0167_ _0215_ _0284_ _0492_ VSS VSS VDD VDD _0493_
+ sky130_fd_sc_hd__a31oi_1
X_1051_ _0241_ _0481_ _0487_ _0489_ _0493_ VSS VSS VDD VDD
+ _0494_ sky130_fd_sc_hd__o2111ai_1
X_1052_ _0148_ _0478_ _0494_ VSS VSS VDD VDD net39 sky130_fd_sc_hd__a21o_1
X_1053_ _0427_ _0428_ VSS VSS VDD VDD _0495_ sky130_fd_sc_hd__nor2_1
X_1054_ _0451_ _0452_ _0495_ _0475_ VSS VSS VDD VDD _0496_
+ sky130_fd_sc_hd__a31o_2
X_1055_ _0098_ _0496_ VSS VSS VDD VDD _0497_ sky130_fd_sc_hd__xor2_1
X_1056_ net6 net19 net17 net15 net61 net60 VSS VSS VDD VDD
+ _0498_ sky130_fd_sc_hd__mux4_2
X_1057_ _0005_ net58 _0498_ VSS VSS VDD VDD _0499_ sky130_fd_sc_hd__nand3_1
X_1058_ net62 net58 _0444_ VSS VSS VDD VDD _0500_ sky130_fd_sc_hd__nand3_1
X_1059_ net61 _0152_ _0303_ VSS VSS VDD VDD _0501_ sky130_fd_sc_hd__nor3_1
X_1060_ _0220_ _0218_ _0219_ _0307_ VSS VSS VDD VDD _0502_
+ sky130_fd_sc_hd__a22o_1
X_1061_ _0501_ _0502_ _0232_ VSS VSS VDD VDD _0503_ sky130_fd_sc_hd__o21ai_0
X_1062_ _0499_ _0500_ _0503_ net59 VSS VSS VDD VDD _0504_
+ sky130_fd_sc_hd__a31oi_1
X_1063_ net16 _0421_ _0479_ VSS VSS VDD VDD _0505_ sky130_fd_sc_hd__nand3_1
X_1064_ _0083_ _0505_ VSS VSS VDD VDD _0506_ sky130_fd_sc_hd__xnor2_1
X_1065_ _0085_ _0237_ VSS VSS VDD VDD _0507_ sky130_fd_sc_hd__nor2_1
X_1066_ net2 net3 _0087_ VSS VSS VDD VDD _0508_ sky130_fd_sc_hd__nand3b_1
X_1067_ net3 _0086_ net2 VSS VSS VDD VDD _0509_ sky130_fd_sc_hd__nand3b_1
X_1068_ _0508_ _0509_ net63 net4 VSS VSS VDD VDD _0510_ sky130_fd_sc_hd__a211oi_1
X_1069_ net61 _0311_ _0312_ _0484_ net58 VSS VSS VDD VDD _0511_
+ sky130_fd_sc_hd__o2111ai_1
X_1070_ _0391_ _0507_ _0510_ _0511_ VSS VSS VDD VDD _0512_
+ sky130_fd_sc_hd__nor4b_1
X_1071_ _0302_ _0308_ _0309_ _0286_ net59 VSS VSS VDD VDD
+ _0513_ sky130_fd_sc_hd__a311o_1
X_1072_ _0241_ _0506_ _0512_ _0513_ VSS VSS VDD VDD _0514_
+ sky130_fd_sc_hd__o211ai_1
X_1073_ _0148_ _0497_ _0504_ _0514_ VSS VSS VDD VDD net38
+ sky130_fd_sc_hd__a211o_1
X_1074_ _0106_ _0117_ VSS VSS VDD VDD _0515_ sky130_fd_sc_hd__nand2_1
X_1075_ _0382_ _0515_ _0384_ _0473_ VSS VSS VDD VDD _0516_
+ sky130_fd_sc_hd__or4b_2
X_1076_ _0098_ _0089_ _0097_ VSS VSS VDD VDD _0517_ sky130_fd_sc_hd__a21o_1
X_1077_ _0106_ _0517_ _0105_ VSS VSS VDD VDD _0518_ sky130_fd_sc_hd__a21o_1
X_1078_ _0429_ _0472_ _0515_ VSS VSS VDD VDD _0519_ sky130_fd_sc_hd__nor3_1
X_1079_ _0117_ _0518_ _0519_ _0116_ VSS VSS VDD VDD _0520_
+ sky130_fd_sc_hd__a211oi_1
X_1080_ _0516_ _0520_ VSS VSS VDD VDD _0521_ sky130_fd_sc_hd__nand2_1
X_1081_ _0114_ _0521_ VSS VSS VDD VDD _0522_ sky130_fd_sc_hd__xor2_1
X_1082_ _0083_ _0091_ _0099_ VSS VSS VDD VDD _0523_ sky130_fd_sc_hd__nor3_1
X_1083_ _0393_ _0479_ _0523_ VSS VSS VDD VDD _0524_ sky130_fd_sc_hd__nand3_1
X_1084_ net9 _0524_ VSS VSS VDD VDD _0525_ sky130_fd_sc_hd__xnor2_1
X_1085_ net9 net7 net20 net18 net61 net60 VSS VSS VDD VDD
+ _0526_ sky130_fd_sc_hd__mux4_2
X_1086_ net62 _0526_ VSS VSS VDD VDD _0527_ sky130_fd_sc_hd__nor2_1
X_1087_ net8 net6 net19 net17 net61 net60 VSS VSS VDD VDD
+ _0528_ sky130_fd_sc_hd__mux4_2
X_1088_ _0005_ _0528_ VSS VSS VDD VDD _0529_ sky130_fd_sc_hd__nor2_1
X_1089_ net59 _0329_ _0527_ _0529_ VSS VSS VDD VDD _0530_
+ sky130_fd_sc_hd__nor4_1
X_1090_ _0109_ VSS VSS VDD VDD _0531_ sky130_fd_sc_hd__inv_1
X_1091_ _0110_ _0531_ net63 VSS VSS VDD VDD _0532_ sky130_fd_sc_hd__mux2i_1
X_1092_ net11 _0223_ _0256_ VSS VSS VDD VDD _0533_ sky130_fd_sc_hd__mux2i_1
X_1093_ _0111_ net56 VSS VSS VDD VDD _0534_ sky130_fd_sc_hd__nand2_1
X_1094_ _0436_ _0532_ _0533_ _0286_ _0534_ VSS VSS VDD VDD
+ _0535_ sky130_fd_sc_hd__o221ai_1
X_1095_ net55 _0525_ _0530_ _0535_ VSS VSS VDD VDD _0536_
+ sky130_fd_sc_hd__a211oi_1
X_1096_ _0132_ _0329_ _0331_ _0332_ VSS VSS VDD VDD _0537_
+ sky130_fd_sc_hd__or4_1
X_1097_ net59 _0339_ _0342_ _0536_ _0537_ VSS VSS VDD VDD
+ _0538_ sky130_fd_sc_hd__o311ai_0
X_1098_ _0148_ _0522_ _0538_ VSS VSS VDD VDD net41 sky130_fd_sc_hd__a21o_1
X_1099_ _0098_ _0496_ _0097_ VSS VSS VDD VDD _0539_ sky130_fd_sc_hd__a21oi_1
X_1100_ _0105_ _0117_ VSS VSS VDD VDD _0540_ sky130_fd_sc_hd__nand2b_1
X_1101_ _0274_ _0540_ VSS VSS VDD VDD _0541_ sky130_fd_sc_hd__nor2_1
X_1102_ _0117_ _0274_ _0539_ _0106_ VSS VSS VDD VDD _0542_
+ sky130_fd_sc_hd__nor4b_1
X_1103_ _0083_ _0091_ _0505_ VSS VSS VDD VDD _0543_ sky130_fd_sc_hd__nor3_1
X_1104_ net8 _0543_ VSS VSS VDD VDD _0544_ sky130_fd_sc_hd__xnor2_1
X_1105_ net59 _0339_ VSS VSS VDD VDD _0545_ sky130_fd_sc_hd__nor2_1
X_1106_ net59 _0373_ _0545_ _0377_ VSS VSS VDD VDD _0546_
+ sky130_fd_sc_hd__a22oi_1
X_1107_ _0117_ _0105_ VSS VSS VDD VDD _0547_ sky130_fd_sc_hd__nand2b_1
X_1108_ _0106_ _0540_ _0547_ VSS VSS VDD VDD _0548_ sky130_fd_sc_hd__o21ai_0
X_1109_ net7 net20 net18 net16 net61 net60 VSS VSS VDD VDD
+ _0549_ sky130_fd_sc_hd__mux4_2
X_1110_ _0528_ _0549_ net62 VSS VSS VDD VDD _0550_ sky130_fd_sc_hd__mux2i_1
X_1111_ net11 _0377_ _0167_ VSS VSS VDD VDD _0551_ sky130_fd_sc_hd__mux2i_1
X_1112_ net59 _0329_ _0550_ _0551_ _0286_ VSS VSS VDD VDD
+ _0552_ sky130_fd_sc_hd__o32ai_1
X_1113_ _0101_ VSS VSS VDD VDD _0553_ sky130_fd_sc_hd__inv_1
X_1114_ _0102_ _0553_ net63 VSS VSS VDD VDD _0554_ sky130_fd_sc_hd__mux2i_1
X_1115_ _0103_ net56 VSS VSS VDD VDD _0555_ sky130_fd_sc_hd__nand2_1
X_1116_ _0436_ _0554_ _0555_ VSS VSS VDD VDD _0556_ sky130_fd_sc_hd__o21ai_0
X_1117_ _0148_ _0548_ _0552_ _0556_ VSS VSS VDD VDD _0557_
+ sky130_fd_sc_hd__a211oi_1
X_1118_ _0241_ _0544_ _0546_ _0557_ VSS VSS VDD VDD _0558_
+ sky130_fd_sc_hd__o211ai_1
X_1119_ _0539_ _0541_ _0542_ _0558_ VSS VSS VDD VDD net40
+ sky130_fd_sc_hd__a211o_1
X_1120_ _0113_ VSS VSS VDD VDD _0559_ sky130_fd_sc_hd__inv_1
X_1121_ _0516_ _0520_ _0114_ VSS VSS VDD VDD _0560_ sky130_fd_sc_hd__a21bo_2
X_1122_ net11 net27 VSS VSS VDD VDD _0561_ sky130_fd_sc_hd__xnor2_1
X_1123_ _0108_ _0119_ _0183_ _0199_ _0156_ VSS VSS VDD VDD
+ _0562_ sky130_fd_sc_hd__a41oi_1
X_1124_ _0561_ _0562_ VSS VSS VDD VDD _0563_ sky130_fd_sc_hd__xnor2_1
X_1125_ _0124_ _0274_ _0563_ VSS VSS VDD VDD _0564_ sky130_fd_sc_hd__nor3_1
X_1126_ _0125_ _0124_ _0274_ _0563_ VSS VSS VDD VDD _0565_
+ sky130_fd_sc_hd__nor4_1
X_1127_ net59 _0400_ VSS VSS VDD VDD _0566_ sky130_fd_sc_hd__nand2_1
X_1128_ net11 net10 net9 net8 net62 net61 VSS VSS VDD VDD
+ _0567_ sky130_fd_sc_hd__mux4_2
X_1129_ net60 _0567_ VSS VSS VDD VDD _0568_ sky130_fd_sc_hd__nor2_1
X_1130_ _0152_ _0482_ VSS VSS VDD VDD _0569_ sky130_fd_sc_hd__nor2_1
X_1131_ _0152_ _0232_ VSS VSS VDD VDD _0570_ sky130_fd_sc_hd__and2_1
X_1132_ net11 _0173_ _0570_ net58 VSS VSS VDD VDD _0571_ sky130_fd_sc_hd__a31oi_1
X_1133_ net59 _0568_ _0569_ _0571_ VSS VSS VDD VDD _0572_
+ sky130_fd_sc_hd__or4_1
X_1134_ net6 net7 net8 net9 VSS VSS VDD VDD _0573_ sky130_fd_sc_hd__and4_1
X_1135_ net10 _0393_ _0479_ _0573_ VSS VSS VDD VDD _0574_
+ sky130_fd_sc_hd__nand4_1
X_1136_ net11 _0574_ VSS VSS VDD VDD _0575_ sky130_fd_sc_hd__xnor2_1
X_1137_ net2 net63 net11 VSS VSS VDD VDD _0576_ sky130_fd_sc_hd__nand3_1
X_1138_ _0130_ _0294_ VSS VSS VDD VDD _0577_ sky130_fd_sc_hd__nand2_1
X_1139_ _0576_ _0577_ VSS VSS VDD VDD _0578_ sky130_fd_sc_hd__nand2_1
X_1140_ _0129_ net57 VSS VSS VDD VDD _0579_ sky130_fd_sc_hd__nand2_1
X_1141_ _0128_ _0237_ _0579_ VSS VSS VDD VDD _0580_ sky130_fd_sc_hd__o21ai_0
X_1142_ net55 _0575_ _0578_ _0249_ _0580_ VSS VSS VDD VDD
+ _0581_ sky130_fd_sc_hd__a221oi_1
X_1143_ _0566_ _0572_ _0581_ VSS VSS VDD VDD _0582_ sky130_fd_sc_hd__nand3_1
X_1144_ _0559_ _0560_ _0564_ _0565_ _0582_ VSS VSS VDD VDD
+ _0583_ sky130_fd_sc_hd__a311oi_1
X_1145_ _0125_ _0148_ _0563_ VSS VSS VDD VDD _0584_ sky130_fd_sc_hd__nand3_1
X_1146_ _0559_ _0560_ _0584_ VSS VSS VDD VDD _0585_ sky130_fd_sc_hd__a21o_1
X_1147_ _0124_ _0148_ _0563_ VSS VSS VDD VDD _0586_ sky130_fd_sc_hd__nand3_1
X_1148_ _0583_ _0585_ _0586_ VSS VSS VDD VDD net43 sky130_fd_sc_hd__nand3_1
X_1149_ _0105_ _0116_ VSS VSS VDD VDD _0587_ sky130_fd_sc_hd__nor2_1
X_1150_ _0106_ _0105_ _0117_ VSS VSS VDD VDD _0588_ sky130_fd_sc_hd__o21a_1
X_1151_ _0116_ _0588_ VSS VSS VDD VDD _0589_ sky130_fd_sc_hd__nor2_1
X_1152_ _0539_ _0587_ _0589_ VSS VSS VDD VDD _0590_ sky130_fd_sc_hd__a21oi_1
X_1153_ _0125_ _0559_ _0148_ VSS VSS VDD VDD _0591_ sky130_fd_sc_hd__nand3_1
X_1154_ _0125_ _0148_ _0114_ VSS VSS VDD VDD _0592_ sky130_fd_sc_hd__nand3b_1
X_1155_ _0539_ _0587_ _0592_ _0589_ VSS VSS VDD VDD _0593_
+ sky130_fd_sc_hd__a211o_1
X_1156_ net16 _0421_ _0479_ _0573_ VSS VSS VDD VDD _0594_
+ sky130_fd_sc_hd__nand4_1
X_1157_ net10 _0594_ VSS VSS VDD VDD _0595_ sky130_fd_sc_hd__xnor2_1
X_1158_ net10 net8 net6 net19 net61 net60 VSS VSS VDD VDD
+ _0596_ sky130_fd_sc_hd__mux4_2
X_1159_ _0526_ _0596_ _0005_ VSS VSS VDD VDD _0597_ sky130_fd_sc_hd__mux2_2
X_1160_ net59 _0597_ net58 VSS VSS VDD VDD _0598_ sky130_fd_sc_hd__o21ai_0
X_1161_ _0339_ _0412_ _0598_ VSS VSS VDD VDD _0599_ sky130_fd_sc_hd__o21ai_0
X_1162_ _0408_ net59 VSS VSS VDD VDD _0600_ sky130_fd_sc_hd__nand2b_1
X_1163_ _0120_ _0237_ VSS VSS VDD VDD _0601_ sky130_fd_sc_hd__nor2_1
X_1164_ _0122_ net56 net57 _0121_ _0601_ VSS VSS VDD VDD _0602_
+ sky130_fd_sc_hd__a221oi_1
X_1165_ _0114_ _0113_ _0125_ VSS VSS VDD VDD _0603_ sky130_fd_sc_hd__or3b_2
X_1166_ _0125_ _0559_ _0603_ VSS VSS VDD VDD _0604_ sky130_fd_sc_hd__o21ai_0
X_1167_ _0148_ _0604_ _0391_ VSS VSS VDD VDD _0605_ sky130_fd_sc_hd__a21oi_1
X_1168_ net59 _0286_ _0411_ _0602_ _0605_ VSS VSS VDD VDD
+ _0606_ sky130_fd_sc_hd__o311ai_0
X_1169_ net55 _0595_ _0599_ _0600_ _0606_ VSS VSS VDD VDD
+ _0607_ sky130_fd_sc_hd__a221oi_1
X_1170_ _0590_ _0591_ _0593_ _0607_ VSS VSS VDD VDD net42
+ sky130_fd_sc_hd__o211ai_1
X_1171_ net5 VSS VSS VDD VDD _0004_ sky130_fd_sc_hd__inv_1
X_1172_ net12 VSS VSS VDD VDD _0011_ sky130_fd_sc_hd__inv_1
X_1173_ net13 VSS VSS VDD VDD _0022_ sky130_fd_sc_hd__inv_1
X_1174_ net10 VSS VSS VDD VDD _0118_ sky130_fd_sc_hd__inv_1
X_1175_ _0148_ _0522_ net40 net39 _0538_ VSS VSS VDD VDD _0608_
+ sky130_fd_sc_hd__a2111o_1
X_1176_ _0353_ _0367_ _0380_ VSS VSS VDD VDD _0609_ sky130_fd_sc_hd__nand3_1
X_1177_ _0322_ _0327_ _0419_ _0274_ VSS VSS VDD VDD _0610_
+ sky130_fd_sc_hd__o2bb2ai_1
X_1178_ net37 _0414_ _0610_ _0426_ VSS VSS VDD VDD _0611_
+ sky130_fd_sc_hd__or4b_1
X_1179_ _0214_ _0235_ _0291_ _0246_ VSS VSS VDD VDD _0612_
+ sky130_fd_sc_hd__o211ai_1
X_1180_ _0300_ _0320_ _0454_ _0470_ VSS VSS VDD VDD _0613_
+ sky130_fd_sc_hd__nand4_1
X_1181_ _0609_ _0611_ _0612_ _0613_ VSS VSS VDD VDD _0614_
+ sky130_fd_sc_hd__or4_1
X_1182_ _0148_ _0431_ net38 _0448_ VSS VSS VDD VDD _0615_
+ sky130_fd_sc_hd__a211o_1
X_1183_ net50 net42 _0614_ _0615_ VSS VSS VDD VDD _0616_ sky130_fd_sc_hd__or4_1
X_1184_ net43 _0608_ _0616_ VSS VSS VDD VDD net53 sky130_fd_sc_hd__nor3_2
X_1185_ net12 _0000_ _0001_ VSS VSS VDD VDD _0002_ _0003_
+ sky130_fd_sc_hd__fa_1
X_1186_ _0004_ _0005_ VSS VSS VDD VDD _0006_ _0007_ sky130_fd_sc_hd__ha_1
X_1187_ _0004_ net62 VSS VSS VDD VDD _0008_ _0617_ sky130_fd_sc_hd__ha_1
X_1188_ net5 _0005_ VSS VSS VDD VDD _0009_ _0618_ sky130_fd_sc_hd__ha_1
X_1189_ net5 net62 VSS VSS VDD VDD _0010_ _0619_ sky130_fd_sc_hd__ha_1
X_1190_ _0011_ _0012_ VSS VSS VDD VDD _0013_ _0014_ sky130_fd_sc_hd__ha_1
X_1191_ net12 net61 VSS VSS VDD VDD _0015_ _0620_ sky130_fd_sc_hd__ha_1
X_1192_ _0005_ _0012_ VSS VSS VDD VDD _0016_ _0017_ sky130_fd_sc_hd__ha_1
X_1193_ net12 _0001_ VSS VSS VDD VDD _0018_ _0019_ sky130_fd_sc_hd__ha_1
X_1194_ net12 net13 VSS VSS VDD VDD _0020_ _0021_ sky130_fd_sc_hd__ha_1
X_1195_ _0022_ _0152_ VSS VSS VDD VDD _0024_ _0025_ sky130_fd_sc_hd__ha_1
X_1196_ net13 net60 VSS VSS VDD VDD _0026_ _0621_ sky130_fd_sc_hd__ha_1
X_1197_ net13 _0027_ VSS VSS VDD VDD _0028_ _0029_ sky130_fd_sc_hd__ha_1
X_1198_ _0030_ _0132_ VSS VSS VDD VDD _0032_ _0033_ sky130_fd_sc_hd__ha_1
X_1199_ net14 net59 VSS VSS VDD VDD _0034_ _0622_ sky130_fd_sc_hd__ha_1
X_1200_ net14 _0035_ VSS VSS VDD VDD _0036_ _0037_ sky130_fd_sc_hd__ha_1
X_1201_ _0038_ _0039_ VSS VSS VDD VDD _0040_ _0041_ sky130_fd_sc_hd__ha_1
X_1202_ net15 net31 VSS VSS VDD VDD _0042_ _0623_ sky130_fd_sc_hd__ha_1
X_1203_ net15 _0043_ VSS VSS VDD VDD _0044_ _0045_ sky130_fd_sc_hd__ha_1
X_1204_ _0046_ _0047_ VSS VSS VDD VDD _0048_ _0049_ sky130_fd_sc_hd__ha_1
X_1205_ net16 net32 VSS VSS VDD VDD _0050_ _0624_ sky130_fd_sc_hd__ha_1
X_1206_ net16 _0051_ VSS VSS VDD VDD _0052_ _0053_ sky130_fd_sc_hd__ha_1
X_1207_ _0054_ _0055_ VSS VSS VDD VDD _0056_ _0057_ sky130_fd_sc_hd__ha_1
X_1208_ net17 net33 VSS VSS VDD VDD _0058_ _0625_ sky130_fd_sc_hd__ha_1
X_1209_ net17 _0059_ VSS VSS VDD VDD _0060_ _0061_ sky130_fd_sc_hd__ha_1
X_1210_ _0062_ _0063_ VSS VSS VDD VDD _0064_ _0065_ sky130_fd_sc_hd__ha_1
X_1211_ net18 net34 VSS VSS VDD VDD _0066_ _0626_ sky130_fd_sc_hd__ha_1
X_1212_ net18 _0067_ VSS VSS VDD VDD _0068_ _0069_ sky130_fd_sc_hd__ha_1
X_1213_ _0070_ _0071_ VSS VSS VDD VDD _0072_ _0073_ sky130_fd_sc_hd__ha_1
X_1214_ net19 net35 VSS VSS VDD VDD _0074_ _0627_ sky130_fd_sc_hd__ha_1
X_1215_ _0075_ _0076_ VSS VSS VDD VDD _0077_ _0078_ sky130_fd_sc_hd__ha_1
X_1216_ net20 net36 VSS VSS VDD VDD _0079_ _0628_ sky130_fd_sc_hd__ha_1
X_1217_ net19 _0080_ VSS VSS VDD VDD _0081_ _0082_ sky130_fd_sc_hd__ha_1
X_1218_ _0083_ _0084_ VSS VSS VDD VDD _0085_ _0086_ sky130_fd_sc_hd__ha_1
X_1219_ net6 net22 VSS VSS VDD VDD _0087_ _0629_ sky130_fd_sc_hd__ha_1
X_1220_ net20 _0088_ VSS VSS VDD VDD _0089_ _0090_ sky130_fd_sc_hd__ha_1
X_1221_ _0091_ _0092_ VSS VSS VDD VDD _0093_ _0094_ sky130_fd_sc_hd__ha_1
X_1222_ net7 net23 VSS VSS VDD VDD _0095_ _0630_ sky130_fd_sc_hd__ha_1
X_1223_ net6 _0096_ VSS VSS VDD VDD _0097_ _0098_ sky130_fd_sc_hd__ha_1
X_1224_ _0099_ _0100_ VSS VSS VDD VDD _0101_ _0102_ sky130_fd_sc_hd__ha_1
X_1225_ net8 net24 VSS VSS VDD VDD _0103_ _0631_ sky130_fd_sc_hd__ha_1
X_1226_ net7 _0104_ VSS VSS VDD VDD _0105_ _0106_ sky130_fd_sc_hd__ha_1
X_1227_ _0107_ _0108_ VSS VSS VDD VDD _0109_ _0110_ sky130_fd_sc_hd__ha_1
X_1228_ net9 net25 VSS VSS VDD VDD _0111_ _0632_ sky130_fd_sc_hd__ha_1
X_1229_ net9 _0112_ VSS VSS VDD VDD _0113_ _0114_ sky130_fd_sc_hd__ha_1
X_1230_ net8 _0115_ VSS VSS VDD VDD _0116_ _0117_ sky130_fd_sc_hd__ha_1
X_1231_ _0118_ _0119_ VSS VSS VDD VDD _0120_ _0121_ sky130_fd_sc_hd__ha_1
X_1232_ net10 net26 VSS VSS VDD VDD _0122_ _0633_ sky130_fd_sc_hd__ha_1
X_1233_ net10 _0123_ VSS VSS VDD VDD _0124_ _0125_ sky130_fd_sc_hd__ha_1
X_1234_ _0126_ _0127_ VSS VSS VDD VDD _0128_ _0129_ sky130_fd_sc_hd__ha_1
X_1235_ net11 net27 VSS VSS VDD VDD _0130_ _0634_ sky130_fd_sc_hd__ha_1
XTAP_TAPCELL_ROW_12_55 VSS VDD sky130_fd_sc_hd__tapvpwrvgnd_1
XTAP_TAPCELL_ROW_13_56 VSS VDD sky130_fd_sc_hd__tapvpwrvgnd_1
XTAP_TAPCELL_ROW_13_57 VSS VDD sky130_fd_sc_hd__tapvpwrvgnd_1
XTAP_TAPCELL_ROW_13_58 VSS VDD sky130_fd_sc_hd__tapvpwrvgnd_1
XTAP_TAPCELL_ROW_13_59 VSS VDD sky130_fd_sc_hd__tapvpwrvgnd_1
XTAP_TAPCELL_ROW_14_60 VSS VDD sky130_fd_sc_hd__tapvpwrvgnd_1
XTAP_TAPCELL_ROW_14_61 VSS VDD sky130_fd_sc_hd__tapvpwrvgnd_1
XTAP_TAPCELL_ROW_14_62 VSS VDD sky130_fd_sc_hd__tapvpwrvgnd_1
XTAP_TAPCELL_ROW_14_63 VSS VDD sky130_fd_sc_hd__tapvpwrvgnd_1
XTAP_TAPCELL_ROW_15_64 VSS VDD sky130_fd_sc_hd__tapvpwrvgnd_1
XTAP_TAPCELL_ROW_15_65 VSS VDD sky130_fd_sc_hd__tapvpwrvgnd_1
XTAP_TAPCELL_ROW_15_66 VSS VDD sky130_fd_sc_hd__tapvpwrvgnd_1
XTAP_TAPCELL_ROW_15_67 VSS VDD sky130_fd_sc_hd__tapvpwrvgnd_1
XTAP_TAPCELL_ROW_16_68 VSS VDD sky130_fd_sc_hd__tapvpwrvgnd_1
XTAP_TAPCELL_ROW_16_69 VSS VDD sky130_fd_sc_hd__tapvpwrvgnd_1
XTAP_TAPCELL_ROW_16_70 VSS VDD sky130_fd_sc_hd__tapvpwrvgnd_1
XTAP_TAPCELL_ROW_16_71 VSS VDD sky130_fd_sc_hd__tapvpwrvgnd_1
XTAP_TAPCELL_ROW_17_72 VSS VDD sky130_fd_sc_hd__tapvpwrvgnd_1
XTAP_TAPCELL_ROW_17_73 VSS VDD sky130_fd_sc_hd__tapvpwrvgnd_1
XTAP_TAPCELL_ROW_17_74 VSS VDD sky130_fd_sc_hd__tapvpwrvgnd_1
XTAP_TAPCELL_ROW_17_75 VSS VDD sky130_fd_sc_hd__tapvpwrvgnd_1
XTAP_TAPCELL_ROW_18_76 VSS VDD sky130_fd_sc_hd__tapvpwrvgnd_1
XTAP_TAPCELL_ROW_18_77 VSS VDD sky130_fd_sc_hd__tapvpwrvgnd_1
XTAP_TAPCELL_ROW_18_78 VSS VDD sky130_fd_sc_hd__tapvpwrvgnd_1
XTAP_TAPCELL_ROW_18_79 VSS VDD sky130_fd_sc_hd__tapvpwrvgnd_1
XTAP_TAPCELL_ROW_19_80 VSS VDD sky130_fd_sc_hd__tapvpwrvgnd_1
XTAP_TAPCELL_ROW_19_81 VSS VDD sky130_fd_sc_hd__tapvpwrvgnd_1
XTAP_TAPCELL_ROW_19_82 VSS VDD sky130_fd_sc_hd__tapvpwrvgnd_1
XTAP_TAPCELL_ROW_19_83 VSS VDD sky130_fd_sc_hd__tapvpwrvgnd_1
XTAP_TAPCELL_ROW_20_84 VSS VDD sky130_fd_sc_hd__tapvpwrvgnd_1
XTAP_TAPCELL_ROW_20_85 VSS VDD sky130_fd_sc_hd__tapvpwrvgnd_1
XTAP_TAPCELL_ROW_20_86 VSS VDD sky130_fd_sc_hd__tapvpwrvgnd_1
XTAP_TAPCELL_ROW_20_87 VSS VDD sky130_fd_sc_hd__tapvpwrvgnd_1
XTAP_TAPCELL_ROW_21_88 VSS VDD sky130_fd_sc_hd__tapvpwrvgnd_1
XTAP_TAPCELL_ROW_21_89 VSS VDD sky130_fd_sc_hd__tapvpwrvgnd_1
XTAP_TAPCELL_ROW_21_90 VSS VDD sky130_fd_sc_hd__tapvpwrvgnd_1
XTAP_TAPCELL_ROW_21_91 VSS VDD sky130_fd_sc_hd__tapvpwrvgnd_1
XTAP_TAPCELL_ROW_22_92 VSS VDD sky130_fd_sc_hd__tapvpwrvgnd_1
XTAP_TAPCELL_ROW_22_93 VSS VDD sky130_fd_sc_hd__tapvpwrvgnd_1
XTAP_TAPCELL_ROW_22_94 VSS VDD sky130_fd_sc_hd__tapvpwrvgnd_1
XTAP_TAPCELL_ROW_22_95 VSS VDD sky130_fd_sc_hd__tapvpwrvgnd_1
XTAP_TAPCELL_ROW_23_96 VSS VDD sky130_fd_sc_hd__tapvpwrvgnd_1
XTAP_TAPCELL_ROW_23_97 VSS VDD sky130_fd_sc_hd__tapvpwrvgnd_1
XTAP_TAPCELL_ROW_23_98 VSS VDD sky130_fd_sc_hd__tapvpwrvgnd_1
XTAP_TAPCELL_ROW_23_99 VSS VDD sky130_fd_sc_hd__tapvpwrvgnd_1
XTAP_TAPCELL_ROW_24_100 VSS VDD sky130_fd_sc_hd__tapvpwrvgnd_1
XTAP_TAPCELL_ROW_24_101 VSS VDD sky130_fd_sc_hd__tapvpwrvgnd_1
XTAP_TAPCELL_ROW_24_102 VSS VDD sky130_fd_sc_hd__tapvpwrvgnd_1
XTAP_TAPCELL_ROW_24_103 VSS VDD sky130_fd_sc_hd__tapvpwrvgnd_1
XTAP_TAPCELL_ROW_25_104 VSS VDD sky130_fd_sc_hd__tapvpwrvgnd_1
XTAP_TAPCELL_ROW_25_105 VSS VDD sky130_fd_sc_hd__tapvpwrvgnd_1
XTAP_TAPCELL_ROW_25_106 VSS VDD sky130_fd_sc_hd__tapvpwrvgnd_1
XTAP_TAPCELL_ROW_25_107 VSS VDD sky130_fd_sc_hd__tapvpwrvgnd_1
XTAP_TAPCELL_ROW_26_108 VSS VDD sky130_fd_sc_hd__tapvpwrvgnd_1
XTAP_TAPCELL_ROW_26_109 VSS VDD sky130_fd_sc_hd__tapvpwrvgnd_1
XTAP_TAPCELL_ROW_26_110 VSS VDD sky130_fd_sc_hd__tapvpwrvgnd_1
XTAP_TAPCELL_ROW_26_111 VSS VDD sky130_fd_sc_hd__tapvpwrvgnd_1
XTAP_TAPCELL_ROW_27_112 VSS VDD sky130_fd_sc_hd__tapvpwrvgnd_1
XTAP_TAPCELL_ROW_27_113 VSS VDD sky130_fd_sc_hd__tapvpwrvgnd_1
XTAP_TAPCELL_ROW_27_114 VSS VDD sky130_fd_sc_hd__tapvpwrvgnd_1
XTAP_TAPCELL_ROW_27_115 VSS VDD sky130_fd_sc_hd__tapvpwrvgnd_1
XTAP_TAPCELL_ROW_28_116 VSS VDD sky130_fd_sc_hd__tapvpwrvgnd_1
XTAP_TAPCELL_ROW_28_117 VSS VDD sky130_fd_sc_hd__tapvpwrvgnd_1
XTAP_TAPCELL_ROW_28_118 VSS VDD sky130_fd_sc_hd__tapvpwrvgnd_1
XTAP_TAPCELL_ROW_28_119 VSS VDD sky130_fd_sc_hd__tapvpwrvgnd_1
XTAP_TAPCELL_ROW_29_120 VSS VDD sky130_fd_sc_hd__tapvpwrvgnd_1
XTAP_TAPCELL_ROW_29_121 VSS VDD sky130_fd_sc_hd__tapvpwrvgnd_1
XTAP_TAPCELL_ROW_29_122 VSS VDD sky130_fd_sc_hd__tapvpwrvgnd_1
XTAP_TAPCELL_ROW_29_123 VSS VDD sky130_fd_sc_hd__tapvpwrvgnd_1
XTAP_TAPCELL_ROW_30_124 VSS VDD sky130_fd_sc_hd__tapvpwrvgnd_1
XTAP_TAPCELL_ROW_30_125 VSS VDD sky130_fd_sc_hd__tapvpwrvgnd_1
XTAP_TAPCELL_ROW_30_126 VSS VDD sky130_fd_sc_hd__tapvpwrvgnd_1
XTAP_TAPCELL_ROW_30_127 VSS VDD sky130_fd_sc_hd__tapvpwrvgnd_1
XTAP_TAPCELL_ROW_31_128 VSS VDD sky130_fd_sc_hd__tapvpwrvgnd_1
XTAP_TAPCELL_ROW_31_129 VSS VDD sky130_fd_sc_hd__tapvpwrvgnd_1
XTAP_TAPCELL_ROW_31_130 VSS VDD sky130_fd_sc_hd__tapvpwrvgnd_1
XTAP_TAPCELL_ROW_31_131 VSS VDD sky130_fd_sc_hd__tapvpwrvgnd_1
XTAP_TAPCELL_ROW_32_132 VSS VDD sky130_fd_sc_hd__tapvpwrvgnd_1
XTAP_TAPCELL_ROW_32_133 VSS VDD sky130_fd_sc_hd__tapvpwrvgnd_1
XTAP_TAPCELL_ROW_32_134 VSS VDD sky130_fd_sc_hd__tapvpwrvgnd_1
XTAP_TAPCELL_ROW_32_135 VSS VDD sky130_fd_sc_hd__tapvpwrvgnd_1
XTAP_TAPCELL_ROW_33_136 VSS VDD sky130_fd_sc_hd__tapvpwrvgnd_1
XTAP_TAPCELL_ROW_33_137 VSS VDD sky130_fd_sc_hd__tapvpwrvgnd_1
XTAP_TAPCELL_ROW_33_138 VSS VDD sky130_fd_sc_hd__tapvpwrvgnd_1
XTAP_TAPCELL_ROW_33_139 VSS VDD sky130_fd_sc_hd__tapvpwrvgnd_1
XTAP_TAPCELL_ROW_34_140 VSS VDD sky130_fd_sc_hd__tapvpwrvgnd_1
XTAP_TAPCELL_ROW_34_141 VSS VDD sky130_fd_sc_hd__tapvpwrvgnd_1
XTAP_TAPCELL_ROW_34_142 VSS VDD sky130_fd_sc_hd__tapvpwrvgnd_1
XTAP_TAPCELL_ROW_34_143 VSS VDD sky130_fd_sc_hd__tapvpwrvgnd_1
XTAP_TAPCELL_ROW_35_144 VSS VDD sky130_fd_sc_hd__tapvpwrvgnd_1
XTAP_TAPCELL_ROW_35_145 VSS VDD sky130_fd_sc_hd__tapvpwrvgnd_1
XTAP_TAPCELL_ROW_35_146 VSS VDD sky130_fd_sc_hd__tapvpwrvgnd_1
XTAP_TAPCELL_ROW_35_147 VSS VDD sky130_fd_sc_hd__tapvpwrvgnd_1
XTAP_TAPCELL_ROW_36_148 VSS VDD sky130_fd_sc_hd__tapvpwrvgnd_1
XTAP_TAPCELL_ROW_36_149 VSS VDD sky130_fd_sc_hd__tapvpwrvgnd_1
XTAP_TAPCELL_ROW_36_150 VSS VDD sky130_fd_sc_hd__tapvpwrvgnd_1
XTAP_TAPCELL_ROW_36_151 VSS VDD sky130_fd_sc_hd__tapvpwrvgnd_1
XTAP_TAPCELL_ROW_37_152 VSS VDD sky130_fd_sc_hd__tapvpwrvgnd_1
XTAP_TAPCELL_ROW_37_153 VSS VDD sky130_fd_sc_hd__tapvpwrvgnd_1
XTAP_TAPCELL_ROW_37_154 VSS VDD sky130_fd_sc_hd__tapvpwrvgnd_1
XTAP_TAPCELL_ROW_37_155 VSS VDD sky130_fd_sc_hd__tapvpwrvgnd_1
XTAP_TAPCELL_ROW_38_156 VSS VDD sky130_fd_sc_hd__tapvpwrvgnd_1
XTAP_TAPCELL_ROW_38_157 VSS VDD sky130_fd_sc_hd__tapvpwrvgnd_1
XTAP_TAPCELL_ROW_38_158 VSS VDD sky130_fd_sc_hd__tapvpwrvgnd_1
XTAP_TAPCELL_ROW_38_159 VSS VDD sky130_fd_sc_hd__tapvpwrvgnd_1
XTAP_TAPCELL_ROW_39_160 VSS VDD sky130_fd_sc_hd__tapvpwrvgnd_1
XTAP_TAPCELL_ROW_39_161 VSS VDD sky130_fd_sc_hd__tapvpwrvgnd_1
XTAP_TAPCELL_ROW_39_162 VSS VDD sky130_fd_sc_hd__tapvpwrvgnd_1
XTAP_TAPCELL_ROW_39_163 VSS VDD sky130_fd_sc_hd__tapvpwrvgnd_1
XTAP_TAPCELL_ROW_40_164 VSS VDD sky130_fd_sc_hd__tapvpwrvgnd_1
XTAP_TAPCELL_ROW_40_165 VSS VDD sky130_fd_sc_hd__tapvpwrvgnd_1
XTAP_TAPCELL_ROW_40_166 VSS VDD sky130_fd_sc_hd__tapvpwrvgnd_1
XTAP_TAPCELL_ROW_40_167 VSS VDD sky130_fd_sc_hd__tapvpwrvgnd_1
XTAP_TAPCELL_ROW_40_168 VSS VDD sky130_fd_sc_hd__tapvpwrvgnd_1
XTAP_TAPCELL_ROW_40_169 VSS VDD sky130_fd_sc_hd__tapvpwrvgnd_1
XTAP_TAPCELL_ROW_40_170 VSS VDD sky130_fd_sc_hd__tapvpwrvgnd_1
XTAP_TAPCELL_ROW_40_171 VSS VDD sky130_fd_sc_hd__tapvpwrvgnd_1
Xinput1 ALU_control[0] VSS VSS VDD VDD net1 sky130_fd_sc_hd__clkdlybuf4s50_1
Xinput2 ALU_control[1] VSS VSS VDD VDD net2 sky130_fd_sc_hd__clkdlybuf4s50_1
Xinput3 ALU_control[2] VSS VSS VDD VDD net3 sky130_fd_sc_hd__clkdlybuf4s50_1
Xinput4 ALU_control[3] VSS VSS VDD VDD net4 sky130_fd_sc_hd__clkdlybuf4s50_1
Xinput5 SrcA[0] VSS VSS VDD VDD net5 sky130_fd_sc_hd__clkdlybuf4s50_1
Xinput6 SrcA[10] VSS VSS VDD VDD net6 sky130_fd_sc_hd__clkdlybuf4s50_1
Xinput7 SrcA[11] VSS VSS VDD VDD net7 sky130_fd_sc_hd__clkdlybuf4s50_1
Xinput8 SrcA[12] VSS VSS VDD VDD net8 sky130_fd_sc_hd__clkdlybuf4s50_1
Xinput9 SrcA[13] VSS VSS VDD VDD net9 sky130_fd_sc_hd__clkdlybuf4s50_1
Xinput10 SrcA[14] VSS VSS VDD VDD net10 sky130_fd_sc_hd__clkdlybuf4s50_1
Xinput11 SrcA[15] VSS VSS VDD VDD net11 sky130_fd_sc_hd__clkdlybuf4s50_1
Xinput12 SrcA[1] VSS VSS VDD VDD net12 sky130_fd_sc_hd__clkdlybuf4s50_1
Xinput13 SrcA[2] VSS VSS VDD VDD net13 sky130_fd_sc_hd__clkdlybuf4s50_1
Xinput14 SrcA[3] VSS VSS VDD VDD net14 sky130_fd_sc_hd__clkdlybuf4s50_1
Xinput15 SrcA[4] VSS VSS VDD VDD net15 sky130_fd_sc_hd__clkdlybuf4s50_1
Xinput16 SrcA[5] VSS VSS VDD VDD net16 sky130_fd_sc_hd__clkdlybuf4s50_1
Xinput17 SrcA[6] VSS VSS VDD VDD net17 sky130_fd_sc_hd__clkdlybuf4s50_1
Xinput18 SrcA[7] VSS VSS VDD VDD net18 sky130_fd_sc_hd__clkdlybuf4s50_1
Xinput19 SrcA[8] VSS VSS VDD VDD net19 sky130_fd_sc_hd__clkdlybuf4s50_1
Xinput20 SrcA[9] VSS VSS VDD VDD net20 sky130_fd_sc_hd__clkdlybuf4s50_1
Xinput21 SrcB[0] VSS VSS VDD VDD net21 sky130_fd_sc_hd__buf_2
Xinput22 SrcB[10] VSS VSS VDD VDD net22 sky130_fd_sc_hd__clkdlybuf4s50_1
Xinput23 SrcB[11] VSS VSS VDD VDD net23 sky130_fd_sc_hd__clkdlybuf4s50_1
Xinput24 SrcB[12] VSS VSS VDD VDD net24 sky130_fd_sc_hd__clkdlybuf4s50_1
Xinput25 SrcB[13] VSS VSS VDD VDD net25 sky130_fd_sc_hd__clkdlybuf4s50_1
Xinput26 SrcB[14] VSS VSS VDD VDD net26 sky130_fd_sc_hd__clkdlybuf4s50_1
Xinput27 SrcB[15] VSS VSS VDD VDD net27 sky130_fd_sc_hd__clkdlybuf4s50_1
Xinput28 SrcB[1] VSS VSS VDD VDD net28 sky130_fd_sc_hd__buf_2
Xinput29 SrcB[2] VSS VSS VDD VDD net29 sky130_fd_sc_hd__clkdlybuf4s50_1
Xinput30 SrcB[3] VSS VSS VDD VDD net30 sky130_fd_sc_hd__clkdlybuf4s50_1
Xinput31 SrcB[4] VSS VSS VDD VDD net31 sky130_fd_sc_hd__clkdlybuf4s50_1
Xinput32 SrcB[5] VSS VSS VDD VDD net32 sky130_fd_sc_hd__clkdlybuf4s50_1
Xinput33 SrcB[6] VSS VSS VDD VDD net33 sky130_fd_sc_hd__clkdlybuf4s50_1
Xinput34 SrcB[7] VSS VSS VDD VDD net34 sky130_fd_sc_hd__clkdlybuf4s50_1
Xinput35 SrcB[8] VSS VSS VDD VDD net35 sky130_fd_sc_hd__clkdlybuf4s50_1
Xinput36 SrcB[9] VSS VSS VDD VDD net36 sky130_fd_sc_hd__clkdlybuf4s50_1
Xoutput37 net37 VSS VSS VDD VDD ALU_result[0] sky130_fd_sc_hd__clkdlybuf4s50_1
Xoutput38 net38 VSS VSS VDD VDD ALU_result[10] sky130_fd_sc_hd__clkdlybuf4s50_1
Xoutput39 net39 VSS VSS VDD VDD ALU_result[11] sky130_fd_sc_hd__clkdlybuf4s50_1
Xoutput40 net40 VSS VSS VDD VDD ALU_result[12] sky130_fd_sc_hd__clkdlybuf4s50_1
Xoutput41 net41 VSS VSS VDD VDD ALU_result[13] sky130_fd_sc_hd__clkdlybuf4s50_1
Xoutput42 net42 VSS VSS VDD VDD ALU_result[14] sky130_fd_sc_hd__clkdlybuf4s50_1
Xoutput43 net43 VSS VSS VDD VDD ALU_result[15] sky130_fd_sc_hd__clkdlybuf4s50_1
Xoutput44 net44 VSS VSS VDD VDD ALU_result[1] sky130_fd_sc_hd__clkdlybuf4s50_1
Xoutput45 net45 VSS VSS VDD VDD ALU_result[2] sky130_fd_sc_hd__clkdlybuf4s50_1
Xoutput46 net46 VSS VSS VDD VDD ALU_result[3] sky130_fd_sc_hd__clkdlybuf4s50_1
Xoutput47 net47 VSS VSS VDD VDD ALU_result[4] sky130_fd_sc_hd__clkdlybuf4s50_1
Xoutput48 net48 VSS VSS VDD VDD ALU_result[5] sky130_fd_sc_hd__clkdlybuf4s50_1
Xoutput49 net49 VSS VSS VDD VDD ALU_result[6] sky130_fd_sc_hd__clkdlybuf4s50_1
Xoutput50 net50 VSS VSS VDD VDD ALU_result[7] sky130_fd_sc_hd__clkdlybuf4s50_1
Xoutput51 net51 VSS VSS VDD VDD ALU_result[8] sky130_fd_sc_hd__clkdlybuf4s50_1
Xoutput52 net52 VSS VSS VDD VDD ALU_result[9] sky130_fd_sc_hd__clkdlybuf4s50_1
Xoutput53 net53 VSS VSS VDD VDD zero sky130_fd_sc_hd__clkdlybuf4s50_1
Xplace62 net21 VSS VSS VDD VDD net62 sky130_fd_sc_hd__buf_4
Xplace55 _0258_ VSS VSS VDD VDD net55 sky130_fd_sc_hd__buf_4
Xplace56 _0243_ VSS VSS VDD VDD net56 sky130_fd_sc_hd__buf_4
Xplace57 _0236_ VSS VSS VDD VDD net57 sky130_fd_sc_hd__buf_4
Xplace58 _0208_ VSS VSS VDD VDD net58 sky130_fd_sc_hd__buf_4
Xplace59 net30 VSS VSS VDD VDD net59 sky130_fd_sc_hd__buf_4
Xplace60 net29 VSS VSS VDD VDD net60 sky130_fd_sc_hd__buf_4
Xplace61 net28 VSS VSS VDD VDD net61 sky130_fd_sc_hd__buf_4
Xplace63 net1 VSS VSS VDD VDD net63 sky130_fd_sc_hd__buf_4
.ENDS ALU
