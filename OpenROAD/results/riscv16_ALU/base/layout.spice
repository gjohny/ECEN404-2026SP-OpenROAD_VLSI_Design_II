* NGSPICE file created from riscv16_ALU.ext - technology: minimum

* Top level circuit riscv16_ALU

.end
